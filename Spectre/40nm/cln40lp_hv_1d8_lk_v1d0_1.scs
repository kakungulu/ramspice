//
simulator lang=spectre insensitive=yes
library tsmclib
//   **********************************************
//   *             TSMC SPICE MODEL               *
//   **********************************************
//
//     PROCESS :  0.040um LOGIC SALICIDE Low-K IMD (Vg=1.8V/Vd=5V) (CLN40LP HVMOS)
//     MODEL   :  BSIM4 ( V4.5 )
//     DOC. NO.:  T-N40-CL-SP-038
//     VERSION :  V1d0_1
//     DATE    :  Jan. 19, 2010
//     SPECTRE VERSION : 7.1.0.048
// *****************************************************************************
//   Updated History:
//   *
//      Date    Version
//   *
//   1. 11/16/09 V1d0_1p1  Newly created Si based 1.8V/5V HVMOS model
//   *
//                         LOD and WPE are not included
//   *
//   2. 01/19/10 V1d0_1    Model copy from V1d0_1p1 for official release
// *****************************************************************************
// *****************************************************************************
//
//   *
//        THIS MODEL LIB CONTAINS :
//   *
//
//   *
//        1.LIB TT_hv18_snw_spw
//   *
//              SS_hv18_snw_spw
//   *
//              FF_hv18_snw_spw
//   *
//              SF_hv18_snw_spw
//   *
//              FS_hv18_snw_spw
//   *
//    ( 1.8V HVMOS devices for standard NW_HVNMOS and PW_HVPMOS with different
//  *
//      geometry and corner models)
//   *
// 									     *
// *****************************************************************************
//
//  NOTE:
//   1. All parasitics capacitances are removed from intrinsic model. The model
//  only
//      covers the intrinsic MOSFET. All parasitic components will be handled
//  by LPE.
//      For pre-layout simulation, contact-to-poly capacitance can be simulated
//  by
//      setting ccoflag_hv18_snw_spw=1.
//
//   2. Best approximation for gate resistance extraction is 1/3 of Rg, DC gate
//
//      resistance. Current LPE tools extract gate resistors from gate edge to
//  center
//      of gate. Error of 1/2 Rg methodology is less than 5% when W/L < 30.  It
//  is
//      recommended to split wide gate transistor to meet W/L < 30 for high precision
//
//      designs. For pre-layout simulation, Rg effect can be simulated by setting
//
//      rgflag_hv18_snw_spw=1
//
// **********************************************************************************

// ***********************    FLAG FOR CONTACT-POLY CAPACITANCE    *******************************
//
//  NOTE: *  1. The default value of ccoflag is 0, which means that the model
//  will exclude contact-to-poly
//      capacitance.  LPE tools should extract this capacitance during post-layout
//  simulation.
//   2. Users could set ccoflag to 1 for pre-layout simulation where contact-to-poly
//  capacitance
//      with maximum contact density is required.
//
// ***********************************************************************************************

section setup_hv18_snw_spw
parameters ccoflag_hv18_snw_spw=0
parameters rgflag_hv18_snw_spw=0
parameters sigma_factor_hv18_snw_spw=1

endsection setup_hv18_snw_spw

// **************************     LIBRARY OF TYPICAL CASE     ***************************

section tt_hv18_snw_spw
include "cln40lp_hv_1d8_lk_v1d0_1.scs" section=setup_hv18_snw_spw
parameters toxn_hv18_snw=3.58e-09
parameters dxln_hv18_snw=0
parameters dxwn_hv18_snw=0
parameters cjdn_hv18_snw=1.35e-4
parameters cjswdn_hv18_snw=5.22e-10
parameters cjswgdn_hv18_snw=6.49e-10
parameters cjsn_hv18_snw=1.4368e-3
parameters cjswsn_hv18_snw=9.73336e-11
parameters cjswgsn_hv18_snw=1.58893e-10
parameters cgdon_hv18_snw=5e-13
parameters cgdln_hv18_snw=4.035e-9
parameters cgson_hv18_snw=4.9271e-11
parameters cgsln_hv18_snw=9.1855e-11
parameters ddlcn_hv18_snw=2.165e-007
parameters dvthn_hv18_snw=0
parameters dlvthn_hv18_snw=0
parameters dwvthn_hv18_snw=0
parameters dpvthn_hv18_snw=0
parameters du0n_hv18_snw=0
parameters dlu0n_hv18_snw=0
parameters dwu0n_hv18_snw=0
parameters dpu0n_hv18_snw=0
parameters dnfactorn_hv18_snw=0
parameters dlnfactorn_hv18_snw=0
parameters dwnfactorn_hv18_snw=0
parameters dpnfactorn_hv18_snw=0
parameters dvsatn_hv18_snw=0
parameters dlvsatn_hv18_snw=0
parameters dwvsatn_hv18_snw=0
parameters dpvsatn_hv18_snw=0
parameters dk2n_hv18_snw=0
parameters dlk2n_hv18_snw=0
parameters dwk2n_hv18_snw=0
parameters dpk2n_hv18_snw=0
parameters deta0n_hv18_snw=0
parameters dweta0n_hv18_snw=0
parameters dcitn_hv18_snw=0
parameters dlcitn_hv18_snw=0
parameters dwcitn_hv18_snw=0
parameters dpcitn_hv18_snw=0
parameters dvoffn_hv18_snw=0
parameters dlvoffn_hv18_snw=0
parameters dwvoffn_hv18_snw=0
parameters dpvoffn_hv18_snw=0
parameters da0n_hv18_snw=0
parameters dla0n_hv18_snw=0
parameters dwa0n_hv18_snw=0
parameters dpa0n_hv18_snw=0
parameters dagsn_hv18_snw=0
parameters dlagsn_hv18_snw=0
parameters dwagsn_hv18_snw=0
parameters dpagsn_hv18_snw=0
parameters dkt1n_hv18_snw=0
parameters dlkt1n_hv18_snw=0
parameters dwkt1n_hv18_snw=0
parameters dpkt1n_hv18_snw=0
parameters datn_hv18_snw=0
parameters dlatn_hv18_snw=0
parameters dwatn_hv18_snw=0
parameters dpatn_hv18_snw=0
parameters djtsswgdn_hv18_snw=0
parameters djtsswgsn_hv18_snw=0
parameters dnjtsswgn_hv18_snw=0
parameters dagidln_hv18_snw=0
parameters dlagidln_hv18_snw=0
parameters dwagidln_hv18_snw=0
parameters dpagidln_hv18_snw=0
parameters dbgidln_hv18_snw=0
parameters dlbgidln_hv18_snw=0
parameters dwbgidln_hv18_snw=0
parameters dpbgidln_hv18_snw=0
parameters ss_flag_hv18_snw_spw=0
parameters ff_flag_hv18_snw_spw=0
parameters sf_flag_hv18_snw_spw=0
parameters fs_flag_hv18_snw_spw=0
parameters cfn_hv18_snw=9.40939e-11 + 5.199e-11 * ccoflag_hv18_snw_spw
parameters toxp_hv18_spw=3.85e-09
parameters dxlp_hv18_spw=0
parameters dxwp_hv18_spw=0
parameters cjdp_hv18_spw=5.95e-04
parameters cjswdp_hv18_spw=3.38e-10
parameters cjswgdp_hv18_spw=7.97e-10
parameters cjsp_hv18_spw=1.31951e-03
parameters cjswsp_hv18_spw=7.12297e-11
parameters cjswgsp_hv18_spw=1.40158e-10
parameters cgdop_hv18_spw=7.73681e-13
parameters cgdlp_hv18_spw=1.238e-9
parameters cgsop_hv18_spw=2.5255e-11
parameters cgslp_hv18_spw=7.2878e-11
parameters ddlcp_hv18_spw=7.45e-08
parameters dvthp_hv18_spw=0
parameters dlvthp_hv18_spw=0
parameters dwvthp_hv18_spw=0
parameters dpvthp_hv18_spw=0
parameters du0p_hv18_spw=0
parameters dlu0p_hv18_spw=0
parameters dwu0p_hv18_spw=0
parameters dpu0p_hv18_spw=0
parameters dnfactorp_hv18_spw=0
parameters dlnfactorp_hv18_spw=0
parameters dwnfactorp_hv18_spw=0
parameters dpnfactorp_hv18_spw=0
parameters dvsatp_hv18_spw=0
parameters dlvsatp_hv18_spw=0
parameters dwvsatp_hv18_spw=0
parameters dpvsatp_hv18_spw=0
parameters dk2p_hv18_spw=0
parameters dlk2p_hv18_spw=0
parameters dwk2p_hv18_spw=0
parameters dpk2p_hv18_spw=0
parameters deta0p_hv18_spw=0
parameters dweta0p_hv18_spw=0
parameters dcitp_hv18_spw=0
parameters dlcitp_hv18_spw=0
parameters dwcitp_hv18_spw=0
parameters dpcitp_hv18_spw=0
parameters dvoffp_hv18_spw=0
parameters dlvoffp_hv18_spw=0
parameters dwvoffp_hv18_spw=0
parameters dpvoffp_hv18_spw=0
parameters da0p_hv18_spw=0
parameters dla0p_hv18_spw=0
parameters dwa0p_hv18_spw=0
parameters dpa0p_hv18_spw=0
parameters dagsp_hv18_spw=0
parameters dlagsp_hv18_spw=0
parameters dwagsp_hv18_spw=0
parameters dpagsp_hv18_spw=0
parameters dkt1p_hv18_spw=0
parameters dlkt1p_hv18_spw=0
parameters dwkt1p_hv18_spw=0
parameters dpkt1p_hv18_spw=0
parameters datp_hv18_spw=0
parameters dlatp_hv18_spw=0
parameters dwatp_hv18_spw=0
parameters dpatp_hv18_spw=0
parameters djtsswgdp_hv18_spw=0
parameters djtsswgsp_hv18_spw=0
parameters dnjtsswgp_hv18_spw=0
parameters dagidlp_hv18_spw=0
parameters dlagidlp_hv18_spw=0
parameters dwagidlp_hv18_spw=0
parameters dpagidlp_hv18_spw=0
parameters dbgidlp_hv18_spw=0
parameters dlbgidlp_hv18_spw=0
parameters dwbgidlp_hv18_spw=0
parameters dpbgidlp_hv18_spw=0
parameters cfp_hv18_spw=9.4395e-11 + 5.737e-11 * ccoflag_hv18_snw_spw
include "cln40lp_hv_1d8_lk_v1d0_1.scs" section=mos_hv18_snw_spw

endsection tt_hv18_snw_spw

// **************************     LIBRARY OF SNSP CORNER CASE     ***************************

section ss_hv18_snw_spw
include "cln40lp_hv_1d8_lk_v1d0_1.scs" section=setup_hv18_snw_spw
parameters a1n_hv18_snw= - 1 * sigma_factor_hv18_snw_spw
parameters a1p_hv18_spw= - 1 * sigma_factor_hv18_snw_spw
parameters a2n_hv18_snw= - 1 * sigma_factor_hv18_snw_spw
parameters a2p_hv18_spw= - 1 * sigma_factor_hv18_snw_spw
parameters a3n_hv18_snw=1 * sigma_factor_hv18_snw_spw
parameters a3p_hv18_spw=1 * sigma_factor_hv18_snw_spw
parameters a4np_hv18_snw_spw= - 1 * sigma_factor_hv18_snw_spw
parameters toxn_hv18_snw=3.58e-09 - 1.333e-010 * a4np_hv18_snw_spw
parameters dxln_hv18_snw= - 8e-009 * a2n_hv18_snw
parameters dxwn_hv18_snw= - 1.2e-008 * a3n_hv18_snw
parameters cjdn_hv18_snw=1.35e-4 * (1 - 0.07 * a1n_hv18_snw)
parameters cjswdn_hv18_snw=5.22e-10 * (1 - 0.07 * a1n_hv18_snw)
parameters cjswgdn_hv18_snw=6.49e-10 * (1 - 0.07 * a1n_hv18_snw)
parameters cjsn_hv18_snw=1.4368e-3 * (1 - 0.07 * a1n_hv18_snw)
parameters cjswsn_hv18_snw=9.73336e-11 * (1 - 0.07 * a1n_hv18_snw)
parameters cjswgsn_hv18_snw=1.58893e-10 * (1 - 0.07 * a1n_hv18_snw)
parameters cgdon_hv18_snw=5e-13 * (1 + 0.07 * a4np_hv18_snw_spw)
parameters cgdln_hv18_snw=4.035e-9 * (1 + 0.07 * a4np_hv18_snw_spw)
parameters cgson_hv18_snw=4.9271e-11 * (1 + 0.07 * a4np_hv18_snw_spw)
parameters cgsln_hv18_snw=9.1855e-11 * (1 + 0.07 * a4np_hv18_snw_spw)
parameters ddlcn_hv18_snw=2.165e-007
parameters dvthn_hv18_snw= - 0.02 * a1n_hv18_snw
parameters dlvthn_hv18_snw= - 1.1e-008 * a1n_hv18_snw
parameters dwvthn_hv18_snw= - 4.5e-009 * a1n_hv18_snw
parameters dpvthn_hv18_snw= - 6.2e-015 * a1n_hv18_snw
parameters du0n_hv18_snw=0.0009 * a1n_hv18_snw
parameters dlu0n_hv18_snw=1.48e-9 * a1n_hv18_snw
parameters dwu0n_hv18_snw= - 3.7e-010 * a1n_hv18_snw
parameters dpu0n_hv18_snw= - 4.5e-016 * a1n_hv18_snw
parameters dnfactorn_hv18_snw=0
parameters dlnfactorn_hv18_snw=0
parameters dwnfactorn_hv18_snw=0
parameters dpnfactorn_hv18_snw=0
parameters dvsatn_hv18_snw= - 30000 * a1n_hv18_snw
parameters dlvsatn_hv18_snw=0
parameters dwvsatn_hv18_snw=4.0e-3 * a1n_hv18_snw
parameters dpvsatn_hv18_snw=0
parameters dk2n_hv18_snw=0
parameters dlk2n_hv18_snw=0
parameters dwk2n_hv18_snw=0
parameters dpk2n_hv18_snw=0
parameters deta0n_hv18_snw=0
parameters dweta0n_hv18_snw=0
parameters dcitn_hv18_snw=0
parameters dlcitn_hv18_snw=0
parameters dwcitn_hv18_snw=0
parameters dpcitn_hv18_snw= - 1.6e-016 * a1n_hv18_snw
parameters dvoffn_hv18_snw=0
parameters dlvoffn_hv18_snw=0
parameters dwvoffn_hv18_snw=0.4e-8 * a1n_hv18_snw
parameters dpvoffn_hv18_snw=0
parameters da0n_hv18_snw=0
parameters dla0n_hv18_snw=0
parameters dwa0n_hv18_snw=0
parameters dpa0n_hv18_snw=0
parameters dagsn_hv18_snw= - 0.01 * a1n_hv18_snw
parameters dlagsn_hv18_snw=1.04e-007 * a1n_hv18_snw
parameters dwagsn_hv18_snw= - 2.9e-008 * a1n_hv18_snw
parameters dpagsn_hv18_snw=0.2e-014 * a1n_hv18_snw
parameters dkt1n_hv18_snw=0
parameters dlkt1n_hv18_snw=0
parameters dwkt1n_hv18_snw=0
parameters dpkt1n_hv18_snw=0
parameters datn_hv18_snw= + 60000 * a1n_hv18_snw
parameters dlatn_hv18_snw=0
parameters dwatn_hv18_snw=0
parameters dpatn_hv18_snw=0
parameters djtsswgdn_hv18_snw=5.5e-008 * a1n_hv18_snw
parameters djtsswgsn_hv18_snw=0
parameters dnjtsswgn_hv18_snw= - 5 * a1n_hv18_snw * 0
parameters dagidln_hv18_snw=0
parameters dlagidln_hv18_snw=0
parameters dwagidln_hv18_snw=0
parameters dpagidln_hv18_snw=0
parameters dbgidln_hv18_snw= - 1.2e+9 * a1n_hv18_snw
parameters dlbgidln_hv18_snw=0
parameters dwbgidln_hv18_snw=0
parameters dpbgidln_hv18_snw=0
parameters ss_flag_hv18_snw_spw=1 * sigma_factor_hv18_snw_spw
parameters ff_flag_hv18_snw_spw=0
parameters sf_flag_hv18_snw_spw=0
parameters fs_flag_hv18_snw_spw=0
parameters cfn_hv18_snw=9.40939e-11 * (1 + 0.07 * a4np_hv18_snw_spw) + 5.199e-11
+ * ccoflag_hv18_snw_spw
parameters toxp_hv18_spw=3.85e-09 - 1.333e-010 * a4np_hv18_snw_spw
parameters dxlp_hv18_spw= - 8e-009 * a2p_hv18_spw
parameters dxwp_hv18_spw= - 1.2e-008 * a3p_hv18_spw
parameters cjdp_hv18_spw=5.95e-04 * (1 - 0.07 * a1p_hv18_spw)
parameters cjswdp_hv18_spw=3.38e-10 * (1 - 0.07 * a1p_hv18_spw)
parameters cjswgdp_hv18_spw=7.97e-10 * (1 - 0.07 * a1p_hv18_spw)
parameters cjsp_hv18_spw=1.31951e-03 * (1 - 0.07 * a1p_hv18_spw)
parameters cjswsp_hv18_spw=7.12297e-11 * (1 - 0.07 * a1p_hv18_spw)
parameters cjswgsp_hv18_spw=1.40158e-10 * (1 - 0.07 * a1p_hv18_spw)
parameters cgdop_hv18_spw=7.73681e-13 * (1 + 0.07 * a4np_hv18_snw_spw)
parameters cgdlp_hv18_spw=1.238e-9 * (1 + 0.07 * a4np_hv18_snw_spw)
parameters cgsop_hv18_spw=2.5255e-11 * (1 + 0.07 * a4np_hv18_snw_spw)
parameters cgslp_hv18_spw=7.2878e-11 * (1 + 0.07 * a4np_hv18_snw_spw)
parameters ddlcp_hv18_spw=7.45e-08
parameters dvthp_hv18_spw=0.02 * a1p_hv18_spw
parameters dlvthp_hv18_spw=1.2e-008 * a1p_hv18_spw
parameters dwvthp_hv18_spw=2.2e-009 * a1p_hv18_spw
parameters dpvthp_hv18_spw=3.0e-015 * a1p_hv18_spw
parameters du0p_hv18_spw= - 0.00002 * a1p_hv18_spw
parameters dlu0p_hv18_spw=2.1e-010 * a1p_hv18_spw
parameters dwu0p_hv18_spw=0.85e-010 * a1p_hv18_spw
parameters dpu0p_hv18_spw= - 1e-017 * a1p_hv18_spw
parameters dnfactorp_hv18_spw=0
parameters dlnfactorp_hv18_spw=0
parameters dwnfactorp_hv18_spw=0
parameters dpnfactorp_hv18_spw=0
parameters dvsatp_hv18_spw=22000 * a1p_hv18_spw
parameters dlvsatp_hv18_spw=0
parameters dwvsatp_hv18_spw= - 3.0e-2 * a1p_hv18_spw
parameters dpvsatp_hv18_spw=0
parameters dk2p_hv18_spw=0
parameters dlk2p_hv18_spw=0
parameters dwk2p_hv18_spw=0
parameters dpk2p_hv18_spw=0
parameters deta0p_hv18_spw=0
parameters dweta0p_hv18_spw=0
parameters dcitp_hv18_spw=3.5e-4 * a1p_hv18_spw
parameters dlcitp_hv18_spw=0
parameters dwcitp_hv18_spw=0
parameters dpcitp_hv18_spw= - 1.5e-16 * a1p_hv18_spw
parameters dvoffp_hv18_spw=0
parameters dlvoffp_hv18_spw=0
parameters dwvoffp_hv18_spw=0
parameters dpvoffp_hv18_spw=0
parameters da0p_hv18_spw=0
parameters dla0p_hv18_spw=0
parameters dwa0p_hv18_spw=0
parameters dpa0p_hv18_spw=0
parameters dagsp_hv18_spw=0
parameters dlagsp_hv18_spw=0
parameters dwagsp_hv18_spw=1.15e-007 * a1p_hv18_spw
parameters dpagsp_hv18_spw= - 1.3e-012 * a1p_hv18_spw
parameters dkt1p_hv18_spw=0
parameters dlkt1p_hv18_spw=0
parameters dwkt1p_hv18_spw=0
parameters dpkt1p_hv18_spw=0
parameters datp_hv18_spw= - 30000 * a1p_hv18_spw
parameters dlatp_hv18_spw=0
parameters dwatp_hv18_spw= + 5e-2 * a1p_hv18_spw
parameters dpatp_hv18_spw=0
parameters djtsswgdp_hv18_spw=4.5e-8 * a1p_hv18_spw
parameters djtsswgsp_hv18_spw=0
parameters dnjtsswgp_hv18_spw= - 6.1 * a1p_hv18_spw
parameters dagidlp_hv18_spw=0
parameters dlagidlp_hv18_spw=0
parameters dwagidlp_hv18_spw=0
parameters dpagidlp_hv18_spw=0
parameters dbgidlp_hv18_spw=0
parameters dlbgidlp_hv18_spw=0
parameters dwbgidlp_hv18_spw=0
parameters dpbgidlp_hv18_spw=0
parameters cfp_hv18_spw=9.4395e-11 * (1 + 0.07 * a4np_hv18_snw_spw) + 5.737e-11
+ * ccoflag_hv18_snw_spw
include "cln40lp_hv_1d8_lk_v1d0_1.scs" section=mos_hv18_snw_spw

endsection ss_hv18_snw_spw

// **************************     LIBRARY OF FNFP CORNER CASE     ***************************

section ff_hv18_snw_spw
include "cln40lp_hv_1d8_lk_v1d0_1.scs" section=setup_hv18_snw_spw
parameters a1n_hv18_snw= - 1 * sigma_factor_hv18_snw_spw
parameters a1p_hv18_spw= - 1 * sigma_factor_hv18_snw_spw
parameters a2n_hv18_snw= - 1 * sigma_factor_hv18_snw_spw
parameters a2p_hv18_spw= - 1 * sigma_factor_hv18_snw_spw
parameters a3n_hv18_snw=1 * sigma_factor_hv18_snw_spw
parameters a3p_hv18_spw=1 * sigma_factor_hv18_snw_spw
parameters a4np_hv18_snw_spw= - 1 * sigma_factor_hv18_snw_spw
parameters toxn_hv18_snw=3.58e-09 + 1.3330e-010 * a4np_hv18_snw_spw
parameters dxln_hv18_snw=8e-009 * a2n_hv18_snw
parameters dxwn_hv18_snw=1.2e-008 * a3n_hv18_snw
parameters cjdn_hv18_snw=1.35e-4 * (1 + 0.070 * a1n_hv18_snw)
parameters cjswdn_hv18_snw=5.22e-10 * (1 + 0.070 * a1n_hv18_snw)
parameters cjswgdn_hv18_snw=6.49e-10 * (1 + 0.070 * a1n_hv18_snw)
parameters cjsn_hv18_snw=1.4368e-3 * (1 + 0.070 * a1n_hv18_snw)
parameters cjswsn_hv18_snw=9.73336e-11 * (1 + 0.070 * a1n_hv18_snw)
parameters cjswgsn_hv18_snw=1.58893e-10 * (1 + 0.070 * a1n_hv18_snw)
parameters cgdon_hv18_snw=5e-13 * (1 - 0.070 * a4np_hv18_snw_spw)
parameters cgdln_hv18_snw=4.035e-9 * (1 - 0.070 * a4np_hv18_snw_spw)
parameters cgson_hv18_snw=4.9271e-11 * (1 - 0.070 * a4np_hv18_snw_spw)
parameters cgsln_hv18_snw=9.1855e-11 * (1 - 0.070 * a4np_hv18_snw_spw)
parameters ddlcn_hv18_snw=2.165e-007
parameters dvthn_hv18_snw=0.02 * a1n_hv18_snw
parameters dlvthn_hv18_snw=1.1e-008 * a1n_hv18_snw
parameters dwvthn_hv18_snw=5.0e-009 * a1n_hv18_snw
parameters dpvthn_hv18_snw=6.0e-015 * a1n_hv18_snw
parameters du0n_hv18_snw= - 0.0008 * a1n_hv18_snw
parameters dlu0n_hv18_snw= - 1.43e-9 * a1n_hv18_snw
parameters dwu0n_hv18_snw=4.0e-010 * a1n_hv18_snw
parameters dpu0n_hv18_snw=5.4e-016 * a1n_hv18_snw
parameters dnfactorn_hv18_snw=0
parameters dlnfactorn_hv18_snw=0
parameters dwnfactorn_hv18_snw=0
parameters dpnfactorn_hv18_snw=0
parameters dvsatn_hv18_snw=10500 * a1n_hv18_snw
parameters dlvsatn_hv18_snw=0
parameters dwvsatn_hv18_snw= - 2.8e-3 * a1n_hv18_snw
parameters dpvsatn_hv18_snw=0
parameters dk2n_hv18_snw=0
parameters dlk2n_hv18_snw=0
parameters dwk2n_hv18_snw=0
parameters dpk2n_hv18_snw=0
parameters deta0n_hv18_snw=0
parameters dweta0n_hv18_snw=0
parameters dcitn_hv18_snw=0.5e-3 * a1n_hv18_snw * 0
parameters dlcitn_hv18_snw=0
parameters dwcitn_hv18_snw=0
parameters dpcitn_hv18_snw=1.8e-016 * a1n_hv18_snw
parameters dvoffn_hv18_snw=0
parameters dlvoffn_hv18_snw= - 0.07e-8 * a1n_hv18_snw
parameters dwvoffn_hv18_snw= - 0.4e-8 * a1n_hv18_snw
parameters dpvoffn_hv18_snw= - 0.5e-15 * a1n_hv18_snw * 0
parameters da0n_hv18_snw=0
parameters dla0n_hv18_snw=0
parameters dwa0n_hv18_snw=0
parameters dpa0n_hv18_snw=0
parameters dagsn_hv18_snw=2.0e-002 * a1n_hv18_snw
parameters dlagsn_hv18_snw= - 1.35e-007 * a1n_hv18_snw
parameters dwagsn_hv18_snw=3.4e-008 * a1n_hv18_snw
parameters dpagsn_hv18_snw= - 0.6e-014 * a1n_hv18_snw
parameters dkt1n_hv18_snw=0
parameters dlkt1n_hv18_snw=0
parameters dwkt1n_hv18_snw=0
parameters dpkt1n_hv18_snw=0
parameters datn_hv18_snw= - 20000 * a1n_hv18_snw
parameters dlatn_hv18_snw=0
parameters dwatn_hv18_snw=0
parameters dpatn_hv18_snw=0
parameters djtsswgdn_hv18_snw= - 5.5e-008 * a1n_hv18_snw
parameters djtsswgsn_hv18_snw=0
parameters dnjtsswgn_hv18_snw=0
parameters dagidln_hv18_snw=0
parameters dlagidln_hv18_snw=0
parameters dwagidln_hv18_snw=0
parameters dpagidln_hv18_snw=0
parameters dbgidln_hv18_snw=1.15e+9 * a1n_hv18_snw
parameters dlbgidln_hv18_snw=0
parameters dwbgidln_hv18_snw= - 70 * a1n_hv18_snw
parameters dpbgidln_hv18_snw=0
parameters ss_flag_hv18_snw_spw=0
parameters ff_flag_hv18_snw_spw=1 * sigma_factor_hv18_snw_spw
parameters sf_flag_hv18_snw_spw=0
parameters fs_flag_hv18_snw_spw=0
parameters cfn_hv18_snw=9.40939e-11 * (1 - 0.070 * a4np_hv18_snw_spw) + 5.199e-11
+ * ccoflag_hv18_snw_spw
parameters toxp_hv18_spw=3.85e-09 + 1.3330e-010 * a4np_hv18_snw_spw
parameters dxlp_hv18_spw=8e-009 * a2p_hv18_spw
parameters dxwp_hv18_spw=1.2e-008 * a3p_hv18_spw
parameters cjdp_hv18_spw=5.95e-04 * (1 + 0.070 * a1p_hv18_spw)
parameters cjswdp_hv18_spw=3.38e-10 * (1 + 0.070 * a1p_hv18_spw)
parameters cjswgdp_hv18_spw=7.97e-10 * (1 + 0.070 * a1p_hv18_spw)
parameters cjsp_hv18_spw=1.31951e-03 * (1 + 0.070 * a1p_hv18_spw)
parameters cjswsp_hv18_spw=7.12297e-11 * (1 + 0.070 * a1p_hv18_spw)
parameters cjswgsp_hv18_spw=1.40158e-10 * (1 + 0.070 * a1p_hv18_spw)
parameters cgdop_hv18_spw=7.73681e-13 * (1 - 0.070 * a4np_hv18_snw_spw)
parameters cgdlp_hv18_spw=1.238e-9 * (1 - 0.070 * a4np_hv18_snw_spw)
parameters cgsop_hv18_spw=2.5255e-11 * (1 - 0.070 * a4np_hv18_snw_spw)
parameters cgslp_hv18_spw=7.2878e-11 * (1 - 0.070 * a4np_hv18_snw_spw)
parameters ddlcp_hv18_spw=7.45e-08
parameters dvthp_hv18_spw= - 0.02 * a1p_hv18_spw
parameters dlvthp_hv18_spw= - 1.15e-008 * a1p_hv18_spw
parameters dwvthp_hv18_spw= - 2.4e-009 * a1p_hv18_spw
parameters dpvthp_hv18_spw= - 2.8e-015 * a1p_hv18_spw
parameters du0p_hv18_spw=0.00004 * a1p_hv18_spw
parameters dlu0p_hv18_spw= - 1.9e-010 * a1p_hv18_spw
parameters dwu0p_hv18_spw= - 0.60e-010 * a1p_hv18_spw
parameters dpu0p_hv18_spw=1.5e-017 * a1p_hv18_spw
parameters dnfactorp_hv18_spw=0
parameters dlnfactorp_hv18_spw=0
parameters dwnfactorp_hv18_spw=0
parameters dpnfactorp_hv18_spw=0
parameters dvsatp_hv18_spw=30000 * a1p_hv18_spw
parameters dlvsatp_hv18_spw=0
parameters dwvsatp_hv18_spw=0.9e-2 * a1p_hv18_spw
parameters dpvsatp_hv18_spw=0
parameters dk2p_hv18_spw=0
parameters dlk2p_hv18_spw=0
parameters dwk2p_hv18_spw=0
parameters dpk2p_hv18_spw=0
parameters deta0p_hv18_spw=0
parameters dweta0p_hv18_spw=0
parameters dcitp_hv18_spw= - 3.5e-4 * a1p_hv18_spw
parameters dlcitp_hv18_spw=0
parameters dwcitp_hv18_spw=0
parameters dpcitp_hv18_spw=1.5e-16 * a1p_hv18_spw
parameters dvoffp_hv18_spw=0
parameters dlvoffp_hv18_spw=0
parameters dwvoffp_hv18_spw=0
parameters dpvoffp_hv18_spw=0
parameters da0p_hv18_spw=0
parameters dla0p_hv18_spw=0
parameters dwa0p_hv18_spw=0
parameters dpa0p_hv18_spw=7e-014 * a1p_hv18_spw
parameters dagsp_hv18_spw=0
parameters dlagsp_hv18_spw=0
parameters dwagsp_hv18_spw= - 2e-008 * a1p_hv18_spw
parameters dpagsp_hv18_spw=4e-013 * a1p_hv18_spw
parameters dkt1p_hv18_spw=0
parameters dlkt1p_hv18_spw=0
parameters dwkt1p_hv18_spw=0
parameters dpkt1p_hv18_spw=0
parameters datp_hv18_spw= - 70000 * a1p_hv18_spw
parameters dlatp_hv18_spw=0
parameters dwatp_hv18_spw= - 3e-2 * a1p_hv18_spw
parameters dpatp_hv18_spw=0
parameters djtsswgdp_hv18_spw= - 4.5e-8 * a1p_hv18_spw
parameters djtsswgsp_hv18_spw=0
parameters dnjtsswgp_hv18_spw=6.1 * a1p_hv18_spw
parameters dagidlp_hv18_spw=0
parameters dlagidlp_hv18_spw=0
parameters dwagidlp_hv18_spw=0
parameters dpagidlp_hv18_spw=0
parameters dbgidlp_hv18_spw=0
parameters dlbgidlp_hv18_spw=0
parameters dwbgidlp_hv18_spw=0
parameters dpbgidlp_hv18_spw=0
parameters cfp_hv18_spw=9.4395e-11 * (1 - 0.070 * a4np_hv18_snw_spw) + 5.737e-11
+ * ccoflag_hv18_snw_spw
include "cln40lp_hv_1d8_lk_v1d0_1.scs" section=mos_hv18_snw_spw

endsection ff_hv18_snw_spw

// **************************     LIBRARY OF SNFP CORNER CASE     ***************************

section sf_hv18_snw_spw
include "cln40lp_hv_1d8_lk_v1d0_1.scs" section=setup_hv18_snw_spw
parameters a1n_hv18_snw=0.8 * sigma_factor_hv18_snw_spw
parameters a1p_hv18_spw= - 0.8 * sigma_factor_hv18_snw_spw
parameters a2n_hv18_snw=0 * sigma_factor_hv18_snw_spw
parameters a2p_hv18_spw=0 * sigma_factor_hv18_snw_spw
parameters a3n_hv18_snw= - 1 * sigma_factor_hv18_snw_spw
parameters a3p_hv18_spw=1 * sigma_factor_hv18_snw_spw
parameters a4np_hv18_snw_spw=0 * sigma_factor_hv18_snw_spw
parameters toxn_hv18_snw=3.58e-09 + 1.3330e-010 * a4np_hv18_snw_spw
parameters dxln_hv18_snw=8e-009 * a2n_hv18_snw
parameters dxwn_hv18_snw=1.2e-008 * a3n_hv18_snw
parameters cjdn_hv18_snw=1.35e-4 * (1 + 0.070 * a1n_hv18_snw)
parameters cjswdn_hv18_snw=5.22e-10 * (1 + 0.070 * a1n_hv18_snw)
parameters cjswgdn_hv18_snw=6.49e-10 * (1 + 0.070 * a1n_hv18_snw)
parameters cjsn_hv18_snw=1.4368e-3 * (1 + 0.070 * a1n_hv18_snw)
parameters cjswsn_hv18_snw=9.73336e-11 * (1 + 0.070 * a1n_hv18_snw)
parameters cjswgsn_hv18_snw=1.58893e-10 * (1 + 0.070 * a1n_hv18_snw)
parameters cgdon_hv18_snw=5e-13 * (1 - 0.070 * a4np_hv18_snw_spw)
parameters cgdln_hv18_snw=4.035e-9 * (1 - 0.070 * a4np_hv18_snw_spw)
parameters cgson_hv18_snw=4.9271e-11 * (1 - 0.070 * a4np_hv18_snw_spw)
parameters cgsln_hv18_snw=9.1855e-11 * (1 - 0.070 * a4np_hv18_snw_spw)
parameters ddlcn_hv18_snw=2.165e-007
parameters dvthn_hv18_snw=0.033 * a1n_hv18_snw
parameters dlvthn_hv18_snw=1.3e-008 * a1n_hv18_snw
parameters dwvthn_hv18_snw=3e-009 * a1n_hv18_snw
parameters dpvthn_hv18_snw=6.5e-015 * a1n_hv18_snw
parameters du0n_hv18_snw= - 0.0008 * a1n_hv18_snw
parameters dlu0n_hv18_snw= - 1.2e-9 * a1n_hv18_snw
parameters dwu0n_hv18_snw=3.7e-010 * a1n_hv18_snw
parameters dpu0n_hv18_snw=5.0e-016 * a1n_hv18_snw
parameters dnfactorn_hv18_snw=0
parameters dlnfactorn_hv18_snw=0
parameters dwnfactorn_hv18_snw=0
parameters dpnfactorn_hv18_snw=0
parameters dvsatn_hv18_snw=10500 * a1n_hv18_snw
parameters dlvsatn_hv18_snw=0
parameters dwvsatn_hv18_snw= - 2.8e-3 * a1n_hv18_snw
parameters dpvsatn_hv18_snw=0
parameters dk2n_hv18_snw=0
parameters dlk2n_hv18_snw=0
parameters dwk2n_hv18_snw=0
parameters dpk2n_hv18_snw=0
parameters deta0n_hv18_snw=0
parameters dweta0n_hv18_snw=0
parameters dcitn_hv18_snw=0
parameters dlcitn_hv18_snw=0
parameters dwcitn_hv18_snw=0
parameters dpcitn_hv18_snw=1.3e-016 * a1n_hv18_snw
parameters dvoffn_hv18_snw=0
parameters dlvoffn_hv18_snw=0
parameters dwvoffn_hv18_snw= - 0.4e-8 * a1n_hv18_snw
parameters dpvoffn_hv18_snw=0
parameters da0n_hv18_snw=0
parameters dla0n_hv18_snw=0
parameters dwa0n_hv18_snw=0
parameters dpa0n_hv18_snw=0
parameters dagsn_hv18_snw=2.0e-002 * a1n_hv18_snw * 0.5
parameters dlagsn_hv18_snw= - 1.35e-007 * a1n_hv18_snw * 0.8
parameters dwagsn_hv18_snw=3.4e-008 * a1n_hv18_snw * 0.5
parameters dpagsn_hv18_snw= - 0.6e-014 * a1n_hv18_snw * 0.5
parameters dkt1n_hv18_snw=0
parameters dlkt1n_hv18_snw=0
parameters dwkt1n_hv18_snw=0
parameters dpkt1n_hv18_snw=0
parameters datn_hv18_snw= - 20000 * a1n_hv18_snw
parameters dlatn_hv18_snw=0
parameters dwatn_hv18_snw=0
parameters dpatn_hv18_snw=0
parameters djtsswgdn_hv18_snw= - 5.5e-008 * a1n_hv18_snw
parameters djtsswgsn_hv18_snw=0
parameters dnjtsswgn_hv18_snw=0
parameters dagidln_hv18_snw=0
parameters dlagidln_hv18_snw=0
parameters dwagidln_hv18_snw=0
parameters dpagidln_hv18_snw=0
parameters dbgidln_hv18_snw=1.15e+9 * a1n_hv18_snw
parameters dlbgidln_hv18_snw=0
parameters dwbgidln_hv18_snw= - 70 * a1n_hv18_snw
parameters dpbgidln_hv18_snw=0
parameters ss_flag_hv18_snw_spw=0
parameters ff_flag_hv18_snw_spw=0
parameters sf_flag_hv18_snw_spw=1 * sigma_factor_hv18_snw_spw
parameters fs_flag_hv18_snw_spw=0
parameters cfn_hv18_snw=9.40939e-11 * (1 - 0.070 * a4np_hv18_snw_spw) + 5.199e-11
+ * ccoflag_hv18_snw_spw
parameters toxp_hv18_spw=3.85e-09 + 1.3330e-010 * a4np_hv18_snw_spw
parameters dxlp_hv18_spw=8e-009 * a2p_hv18_spw
parameters dxwp_hv18_spw=1.2e-008 * a3p_hv18_spw
parameters cjdp_hv18_spw=5.95e-04 * (1 + 0.070 * a1p_hv18_spw)
parameters cjswdp_hv18_spw=3.38e-10 * (1 + 0.070 * a1p_hv18_spw)
parameters cjswgdp_hv18_spw=7.97e-10 * (1 + 0.070 * a1p_hv18_spw)
parameters cjsp_hv18_spw=1.31951e-03 * (1 + 0.070 * a1p_hv18_spw)
parameters cjswsp_hv18_spw=7.12297e-11 * (1 + 0.070 * a1p_hv18_spw)
parameters cjswgsp_hv18_spw=1.40158e-10 * (1 + 0.070 * a1p_hv18_spw)
parameters cgdop_hv18_spw=7.73681e-13 * (1 - 0.070 * a4np_hv18_snw_spw)
parameters cgdlp_hv18_spw=1.238e-9 * (1 - 0.070 * a4np_hv18_snw_spw)
parameters cgsop_hv18_spw=2.5255e-11 * (1 - 0.070 * a4np_hv18_snw_spw)
parameters cgslp_hv18_spw=7.2878e-11 * (1 - 0.070 * a4np_hv18_snw_spw)
parameters ddlcp_hv18_spw=7.45e-08
parameters dvthp_hv18_spw= - 0.033 * a1p_hv18_spw
parameters dlvthp_hv18_spw= - 1.3e-008 * a1p_hv18_spw
parameters dwvthp_hv18_spw= - 2.1e-009 * a1p_hv18_spw
parameters dpvthp_hv18_spw= - 3.3e-015 * a1p_hv18_spw
parameters du0p_hv18_spw= - 0.0001 * a1p_hv18_spw
parameters dlu0p_hv18_spw= - 2.2e-010 * a1p_hv18_spw
parameters dwu0p_hv18_spw= - 0.30e-010 * a1p_hv18_spw
parameters dpu0p_hv18_spw=1.5e-017 * a1p_hv18_spw
parameters dnfactorp_hv18_spw=0
parameters dlnfactorp_hv18_spw=0
parameters dwnfactorp_hv18_spw=0
parameters dpnfactorp_hv18_spw=0
parameters dvsatp_hv18_spw=18000 * a1p_hv18_spw
parameters dlvsatp_hv18_spw=0
parameters dwvsatp_hv18_spw=1.6e-2 * a1p_hv18_spw
parameters dpvsatp_hv18_spw=0
parameters dk2p_hv18_spw=0
parameters dlk2p_hv18_spw=0
parameters dwk2p_hv18_spw=0
parameters dpk2p_hv18_spw=0
parameters deta0p_hv18_spw=0
parameters dweta0p_hv18_spw=0
parameters dcitp_hv18_spw= - 3.5e-4 * a1p_hv18_spw
parameters dlcitp_hv18_spw=0
parameters dwcitp_hv18_spw=0
parameters dpcitp_hv18_spw=2e-16 * a1p_hv18_spw
parameters dvoffp_hv18_spw=0
parameters dlvoffp_hv18_spw=0
parameters dwvoffp_hv18_spw=0
parameters dpvoffp_hv18_spw=0
parameters da0p_hv18_spw=0
parameters dla0p_hv18_spw=0
parameters dwa0p_hv18_spw=0
parameters dpa0p_hv18_spw=7e-014 * a1p_hv18_spw * 0
parameters dagsp_hv18_spw=0
parameters dlagsp_hv18_spw=0
parameters dwagsp_hv18_spw= - 2e-008 * a1p_hv18_spw
parameters dpagsp_hv18_spw=4e-013 * a1p_hv18_spw
parameters dkt1p_hv18_spw=0
parameters dlkt1p_hv18_spw=0
parameters dwkt1p_hv18_spw=0
parameters dpkt1p_hv18_spw=0
parameters datp_hv18_spw= - 30000 * a1p_hv18_spw
parameters dlatp_hv18_spw=0
parameters dwatp_hv18_spw= - 5e-2 * a1p_hv18_spw
parameters dpatp_hv18_spw=0
parameters djtsswgdp_hv18_spw= - 4.5e-8 * a1p_hv18_spw
parameters djtsswgsp_hv18_spw=0
parameters dnjtsswgp_hv18_spw=6.1 * a1p_hv18_spw
parameters dagidlp_hv18_spw=0
parameters dlagidlp_hv18_spw=0
parameters dwagidlp_hv18_spw=0
parameters dpagidlp_hv18_spw=0
parameters dbgidlp_hv18_spw=0
parameters dlbgidlp_hv18_spw=0
parameters dwbgidlp_hv18_spw=0
parameters dpbgidlp_hv18_spw=0
parameters cfp_hv18_spw=9.4395e-11 * (1 - 0.070 * a4np_hv18_snw_spw) + 5.737e-11
+ * ccoflag_hv18_snw_spw
include "cln40lp_hv_1d8_lk_v1d0_1.scs" section=mos_hv18_snw_spw

endsection sf_hv18_snw_spw

// **************************     LIBRARY OF FNSP CORNER CASE     ***************************

section fs_hv18_snw_spw
include "cln40lp_hv_1d8_lk_v1d0_1.scs" section=setup_hv18_snw_spw
parameters a1n_hv18_snw= - 0.8 * sigma_factor_hv18_snw_spw
parameters a1p_hv18_spw=0.8 * sigma_factor_hv18_snw_spw
parameters a2n_hv18_snw=0 * sigma_factor_hv18_snw_spw
parameters a2p_hv18_spw=0 * sigma_factor_hv18_snw_spw
parameters a3n_hv18_snw=1 * sigma_factor_hv18_snw_spw
parameters a3p_hv18_spw= - 1 * sigma_factor_hv18_snw_spw
parameters a4np_hv18_snw_spw=0 * sigma_factor_hv18_snw_spw
parameters toxn_hv18_snw=3.58e-09 + 1.3330e-010 * a4np_hv18_snw_spw
parameters dxln_hv18_snw=8e-009 * a2n_hv18_snw
parameters dxwn_hv18_snw=1.2e-008 * a3n_hv18_snw
parameters cjdn_hv18_snw=1.35e-4 * (1 + 0.070 * a1n_hv18_snw)
parameters cjswdn_hv18_snw=5.22e-10 * (1 + 0.070 * a1n_hv18_snw)
parameters cjswgdn_hv18_snw=6.49e-10 * (1 + 0.070 * a1n_hv18_snw)
parameters cjsn_hv18_snw=1.4368e-3 * (1 + 0.070 * a1n_hv18_snw)
parameters cjswsn_hv18_snw=9.73336e-11 * (1 + 0.070 * a1n_hv18_snw)
parameters cjswgsn_hv18_snw=1.58893e-10 * (1 + 0.070 * a1n_hv18_snw)
parameters cgdon_hv18_snw=5e-13 * (1 - 0.070 * a4np_hv18_snw_spw)
parameters cgdln_hv18_snw=4.035e-9 * (1 - 0.070 * a4np_hv18_snw_spw)
parameters cgson_hv18_snw=4.9271e-11 * (1 - 0.070 * a4np_hv18_snw_spw)
parameters cgsln_hv18_snw=9.1855e-11 * (1 - 0.070 * a4np_hv18_snw_spw)
parameters ddlcn_hv18_snw=2.165e-007
parameters dvthn_hv18_snw=0.033 * a1n_hv18_snw
parameters dlvthn_hv18_snw=1.3e-008 * a1n_hv18_snw
parameters dwvthn_hv18_snw=3e-009 * a1n_hv18_snw
parameters dpvthn_hv18_snw=6.5e-015 * a1n_hv18_snw
parameters du0n_hv18_snw= - 0.0008 * a1n_hv18_snw
parameters dlu0n_hv18_snw= - 1.2e-9 * a1n_hv18_snw
parameters dwu0n_hv18_snw=3.7e-010 * a1n_hv18_snw
parameters dpu0n_hv18_snw=5.0e-016 * a1n_hv18_snw
parameters dnfactorn_hv18_snw=0
parameters dlnfactorn_hv18_snw=0
parameters dwnfactorn_hv18_snw=0
parameters dpnfactorn_hv18_snw=0
parameters dvsatn_hv18_snw=10500 * a1n_hv18_snw
parameters dlvsatn_hv18_snw=0
parameters dwvsatn_hv18_snw= - 2.8e-3 * a1n_hv18_snw
parameters dpvsatn_hv18_snw=0
parameters dk2n_hv18_snw=0
parameters dlk2n_hv18_snw=0
parameters dwk2n_hv18_snw=0
parameters dpk2n_hv18_snw=0
parameters deta0n_hv18_snw=0
parameters dweta0n_hv18_snw=0
parameters dcitn_hv18_snw=0
parameters dlcitn_hv18_snw=0
parameters dwcitn_hv18_snw=0
parameters dpcitn_hv18_snw=1.3e-016 * a1n_hv18_snw
parameters dvoffn_hv18_snw=0
parameters dlvoffn_hv18_snw=0
parameters dwvoffn_hv18_snw= - 0.4e-8 * a1n_hv18_snw
parameters dpvoffn_hv18_snw=0
parameters da0n_hv18_snw=0
parameters dla0n_hv18_snw=0
parameters dwa0n_hv18_snw=0
parameters dpa0n_hv18_snw=0
parameters dagsn_hv18_snw=2.0e-002 * a1n_hv18_snw * 0.5
parameters dlagsn_hv18_snw= - 1.35e-007 * a1n_hv18_snw * 0.8
parameters dwagsn_hv18_snw=3.4e-008 * a1n_hv18_snw * 0.5
parameters dpagsn_hv18_snw= - 0.6e-014 * a1n_hv18_snw * 0.5
parameters dkt1n_hv18_snw=0
parameters dlkt1n_hv18_snw=0
parameters dwkt1n_hv18_snw=0
parameters dpkt1n_hv18_snw=0
parameters datn_hv18_snw= - 20000 * a1n_hv18_snw
parameters dlatn_hv18_snw=0
parameters dwatn_hv18_snw=0
parameters dpatn_hv18_snw=0
parameters djtsswgdn_hv18_snw= - 5.5e-008 * a1n_hv18_snw
parameters djtsswgsn_hv18_snw=0
parameters dnjtsswgn_hv18_snw=0
parameters dagidln_hv18_snw=0
parameters dlagidln_hv18_snw=0
parameters dwagidln_hv18_snw=0
parameters dpagidln_hv18_snw=0
parameters dbgidln_hv18_snw=1.15e+9 * a1n_hv18_snw
parameters dlbgidln_hv18_snw=0
parameters dwbgidln_hv18_snw= - 70 * a1n_hv18_snw
parameters dpbgidln_hv18_snw=0
parameters ss_flag_hv18_snw_spw=0
parameters ff_flag_hv18_snw_spw=0
parameters sf_flag_hv18_snw_spw=0
parameters fs_flag_hv18_snw_spw=1 * sigma_factor_hv18_snw_spw
parameters cfn_hv18_snw=9.40939e-11 * (1 - 0.070 * a4np_hv18_snw_spw) + 5.199e-11
+ * ccoflag_hv18_snw_spw
parameters toxp_hv18_spw=3.85e-09 + 1.3330e-010 * a4np_hv18_snw_spw
parameters dxlp_hv18_spw=8e-009 * a2p_hv18_spw
parameters dxwp_hv18_spw=1.2e-008 * a3p_hv18_spw
parameters cjdp_hv18_spw=5.95e-04 * (1 + 0.070 * a1p_hv18_spw)
parameters cjswdp_hv18_spw=3.38e-10 * (1 + 0.070 * a1p_hv18_spw)
parameters cjswgdp_hv18_spw=7.97e-10 * (1 + 0.070 * a1p_hv18_spw)
parameters cjsp_hv18_spw=1.31951e-03 * (1 + 0.070 * a1p_hv18_spw)
parameters cjswsp_hv18_spw=7.12297e-11 * (1 + 0.070 * a1p_hv18_spw)
parameters cjswgsp_hv18_spw=1.40158e-10 * (1 + 0.070 * a1p_hv18_spw)
parameters cgdop_hv18_spw=7.73681e-13 * (1 - 0.070 * a4np_hv18_snw_spw)
parameters cgdlp_hv18_spw=1.238e-9 * (1 - 0.070 * a4np_hv18_snw_spw)
parameters cgsop_hv18_spw=2.5255e-11 * (1 - 0.070 * a4np_hv18_snw_spw)
parameters cgslp_hv18_spw=7.2878e-11 * (1 - 0.070 * a4np_hv18_snw_spw)
parameters ddlcp_hv18_spw=7.45e-08
parameters dvthp_hv18_spw= - 0.033 * a1p_hv18_spw
parameters dlvthp_hv18_spw= - 1.3e-008 * a1p_hv18_spw
parameters dwvthp_hv18_spw= - 2.1e-009 * a1p_hv18_spw
parameters dpvthp_hv18_spw= - 3.3e-015 * a1p_hv18_spw
parameters du0p_hv18_spw= - 0.0001 * a1p_hv18_spw
parameters dlu0p_hv18_spw= - 2.2e-010 * a1p_hv18_spw
parameters dwu0p_hv18_spw= - 0.30e-010 * a1p_hv18_spw
parameters dpu0p_hv18_spw=1.5e-017 * a1p_hv18_spw
parameters dnfactorp_hv18_spw=0
parameters dlnfactorp_hv18_spw=0
parameters dwnfactorp_hv18_spw=0
parameters dpnfactorp_hv18_spw=0
parameters dvsatp_hv18_spw=18000 * a1p_hv18_spw
parameters dlvsatp_hv18_spw=0
parameters dwvsatp_hv18_spw=1.6e-2 * a1p_hv18_spw
parameters dpvsatp_hv18_spw=0
parameters dk2p_hv18_spw=0
parameters dlk2p_hv18_spw=0
parameters dwk2p_hv18_spw=0
parameters dpk2p_hv18_spw=0
parameters deta0p_hv18_spw=0
parameters dweta0p_hv18_spw=0
parameters dcitp_hv18_spw= - 3.5e-4 * a1p_hv18_spw
parameters dlcitp_hv18_spw=0
parameters dwcitp_hv18_spw=0
parameters dpcitp_hv18_spw=2e-16 * a1p_hv18_spw
parameters dvoffp_hv18_spw=0
parameters dlvoffp_hv18_spw=0
parameters dwvoffp_hv18_spw=0
parameters dpvoffp_hv18_spw=0
parameters da0p_hv18_spw=0
parameters dla0p_hv18_spw=0
parameters dwa0p_hv18_spw=0
parameters dpa0p_hv18_spw=7e-014 * a1p_hv18_spw * 0
parameters dagsp_hv18_spw=0
parameters dlagsp_hv18_spw=0
parameters dwagsp_hv18_spw= - 2e-008 * a1p_hv18_spw * 1
parameters dpagsp_hv18_spw=4e-013 * a1p_hv18_spw * 1
parameters dkt1p_hv18_spw=0
parameters dlkt1p_hv18_spw=0
parameters dwkt1p_hv18_spw=0
parameters dpkt1p_hv18_spw=0
parameters datp_hv18_spw= - 30000 * a1p_hv18_spw
parameters dlatp_hv18_spw=0
parameters dwatp_hv18_spw= - 5e-2 * a1p_hv18_spw
parameters dpatp_hv18_spw=0
parameters djtsswgdp_hv18_spw= - 4.5e-8 * a1p_hv18_spw
parameters djtsswgsp_hv18_spw=0
parameters dnjtsswgp_hv18_spw=6.1 * a1p_hv18_spw
parameters dagidlp_hv18_spw=0
parameters dlagidlp_hv18_spw=0
parameters dwagidlp_hv18_spw=0
parameters dpagidlp_hv18_spw=0
parameters dbgidlp_hv18_spw=0
parameters dlbgidlp_hv18_spw=0
parameters dwbgidlp_hv18_spw=0
parameters dpbgidlp_hv18_spw=0
parameters cfp_hv18_spw=9.4395e-11 * (1 - 0.070 * a4np_hv18_snw_spw) + 5.737e-11
+ * ccoflag_hv18_snw_spw
include "cln40lp_hv_1d8_lk_v1d0_1.scs" section=mos_hv18_snw_spw

endsection fs_hv18_snw_spw

// **************************************************************
//                                                              *
//                      1.8V IO DEVICE MODELS                   *
//                                                              *
// **************************************************************

section mos_hv18_snw_spw
// *********************************************************************************************
//
//                   *
//                                 1.8V NMOS HVMOS DEVICE MODELS
//                     *
//
//                   *
// *********************************************************************************************

model nch_hv18_snw bsim4  {
     1: type=n
+ lmin=1e-005-dxln_hv18_snw lmax=900.001e-06          wmin=2e-005-dxwn_hv18_snw
+ wmax=900.001e-06          version=4.5               binunit=2
+ paramchk=1                mobmod=0                  capmod=2
+ igcmod=0                  igbmod=0                  diomod=1
+ rdsmod=1                  rbodymod=0                rgeomod=1
+ rgatemod=1*rgflag_hv18_snw_spw                      permod=1
+ acnqsmod=0                trnqsmod=0                tempmod=0
+ tnom=25                   toxe=toxn_hv18_snw        toxm=3.58e-009
+ dtox=2.7936e-010          epsrox=3.9                wint=0
+ lint=2.45e-007            ll=0                      wl=0
+ lln=1                     wln=1                     lw=0
+ ww=0                      lwn=1                     wwn=1
+ lwl=0                     wwl=0                     llc=0
+ wlc=0                     lwc=0                     wwc=0
+ lwlc=0                    wwlc=0                    xl=1e-08+dxln_hv18_snw
+ xw=0+dxwn_hv18_snw        dlc=ddlcn_hv18_snw        dwc=0
+ xpart=1                   toxref=3e-009             dlcig=2.5e-009
+ vth0=0.56304004+dvthn_hv18_snw                      k1=0.24874
+ k2=0.060967+dk2n_hv18_snw k3=-1.82                  k3b=1.0692
+ w0=0                      dvt0=1.1319               dvt1=0.0055
+ dvt2=0.00050391           dvt0w=0                   dvt1w=0
+ dvt2w=0                   dsub=0.25                 minv=-0.4444
+ voffl=-5e-009             dvtp0=2.1516e-007         dvtp1=0.01
+ lpe0=5e-007               lpeb=2.4075e-007          xj=6.7e-008
+ ngate=8.5997e+020         ndep=9e+017               nsd=1e+020
+ phin=0.185                cdsc=0                    cdscb=0
+ cdscd=0                   cit=0.00024352905+dcitn_hv18_snw
+ voff=-0.17463011+dvoffn_hv18_snw                    nfactor=0.6+dnfactorn_hv18_snw
+ eta0=0.0010241+deta0n_hv18_snw                      etab=-0.053029168
+ ud=0                      lud=0                     wud=0
+ pud=0                     u0=0.034217011+du0n_hv18_snw
+ ua=-7.6779019e-010        ub=2.2034e-018            uc=1.1337e-010
+ vsat=160000+dvsatn_hv18_snw                         a0=2.1904016+da0n_hv18_snw
+ ags=0.64373001+dagsn_hv18_snw                       a1=0
+ a2=1                      b0=0                      b1=0
+ keta=-0.046167986         dwg=0                     dwb=0
+ pclm=0.014996             pdiblc1=0                 pdiblc2=0.0001
+ pdiblcb=0                 drout=0.56                pvag=0.45
+ delta=0.01                pscbe1=9.264e+008         pscbe2=1e-020
+ fprout=100                pdits=0                   pditsd=0
+ pditsl=0                  rsh=17.5                  rsw=65.35
+ rdw=600                   prwg=0                    prwb=0
+ wr=1                      alpha0=6.3669e-08         alpha1=1.5
+ beta0=29.5                agidl=4e-009+dagidln_hv18_snw
+ bgidl=8e+009+dbgidln_hv18_snw                       cgidl=21.599
+ egidl=0.55661             aigbacc=0.01238           bigbacc=0.006109
+ cigbacc=0.2809            nigbacc=4.05              aigbinv=0.02
+ bigbinv=0.02              cigbinv=0.006             eigbinv=1.1
+ nigbinv=1                 aigc=0.009898             bigc=0.001383
+ cigc=1.515e-005           aigsd=0.0086              bigsd=0.0004353
+ cigsd=3.925e-020          nigc=1                    poxedge=1
+ pigcd=1.672               ntox=1                    xrcrg1=12
+ xrcrg2=1                  cgso=cgson_hv18_snw       cgdo=cgdon_hv18_snw
+ cgbo=0                    cgdl=cgdln_hv18_snw       cgsl=cgsln_hv18_snw
+ clc=1e-007                cle=0.6                   cf=cfn_hv18_snw
+ ckappas=0.6               ckappad=0.6               acde=0.3
+ moin=5.2                  noff=2.9337               voffcv=-0.16925
+ tvoff=0.001               ltvoff=0                  wtvoff=0
+ ptvoff=0                  kt1=-0.1919+dkt1n_hv18_snw
+ kt1l=0                    kt2=-0.045284             ute=-1.35
+ ua1=1.3537e-009           ub1=-1.6783e-018          uc1=1.1462e-010
+ prt=0                     at=6.1207342e-005+datn_hv18_snw
+ jss=5.23e-007             jsws=2.52e-013            jswgs=2.52e-013
+ njs=1.02                  njd=1.02                  ijthsfwd=0.01
+ ijthdfwd=0.01             ijthsrev=0.01             ijthdrev=0.01
+ bvs=8.4                   xjbvs=1                   xjbvd=1
+ jsd=1.03e-006             jswd=1.14e-012            jswgd=1.14e-012
+ bvd=14.1                  jtsswgs=3e-009+djtsswgsn_hv18_snw
+ jtsswgd=6e-008+djtsswgdn_hv18_snw                   njtsswg=20+dnjtsswgn_hv18_snw
+ xtsswgs=0.1               xtsswgd=0.75              tnjtsswg=0.5
+ vtsswgs=0.7               vtsswgd=0.05              pbs=0.5
+ cjs=cjsn_hv18_snw         mjs=0.24                  pbsws=0.3
+ cjsws=cjswsn_hv18_snw     mjsws=0.013               pbswgs=0.5
+ cjswgs=cjswgsn_hv18_snw   mjswgs=0.3                pbd=0.56
+ cjd=cjdn_hv18_snw         mjd=0.36                  pbswd=0.8
+ cjswd=cjswdn_hv18_snw     mjswd=0.31                pbswgd=0.8
+ cjswgd=cjswgdn_hv18_snw   mjswgd=0.36               tpb=0.002
+ tcj=0.0018                tpbsw=0.0025              tcjsw=0.0011
+ tpbswg=0.0028             tcjswg=0.00157            xtis=3
+ xtid=3                    dmcg=6.4e-08              dmci=6.4e-08
+ dmdg=0                    dmcgt=0                   dwj=0
+ xgw=0                     xgl=-1.09e-08             rshg=15.6
+ gbmin=1e-012              rbpb=50                   rbpd=50
+ rbps=50                   rbdb=50                   rbsb=50
+ ngcon=1                   lvth0=0+dlvthn_hv18_snw   wvth0=0+dwvthn_hv18_snw
+ pvth0=0+dpvthn_hv18_snw   lu0=0+dlu0n_hv18_snw      wu0=0+dwu0n_hv18_snw
+ pu0=0+dpu0n_hv18_snw      la0=0+dla0n_hv18_snw      wa0=0+dwa0n_hv18_snw
+ pa0=0+dpa0n_hv18_snw      lags=0+dlagsn_hv18_snw    wags=0+dwagsn_hv18_snw
+ pags=0+dpagsn_hv18_snw    lvsat=0+dlvsatn_hv18_snw  wnfactor=0+dwnfactorn_hv18_snw
+ lnfactor=0+dlnfactorn_hv18_snw                      pnfactor=0+dpnfactorn_hv18_snw
+ pvsat=0+dpvsatn_hv18_snw  wvsat=0+dwvsatn_hv18_snw  lk2=0+dlk2n_hv18_snw
+ wk2=0+dwk2n_hv18_snw      pk2=0+dpk2n_hv18_snw      weta0=0+dweta0n_hv18_snw
+ lcit=0+dlcitn_hv18_snw    wcit=0+dwcitn_hv18_snw    pcit=0+dpcitn_hv18_snw
+ lvoff=0+dlvoffn_hv18_snw  wvoff=0+dwvoffn_hv18_snw  pvoff=0+dpvoffn_hv18_snw
+ lkt1=0+dlkt1n_hv18_snw    wkt1=0+dwkt1n_hv18_snw    pkt1=0+dpkt1n_hv18_snw
+ lat=0+dlatn_hv18_snw      wat=0+dwatn_hv18_snw      pat=0+dpatn_hv18_snw
+ lagidl=0+dlagidln_hv18_snw                          wagidl=0+dwagidln_hv18_snw
+ pagidl=0+dpagidln_hv18_snw                          lbgidl=0+dlbgidln_hv18_snw
+ wbgidl=0+dwbgidln_hv18_snw                          pbgidl=0+dpbgidln_hv18_snw
+ minr=1e-3

     2: type=n
+ lmin=1e-006-dxln_hv18_snw lmax=1e-005-dxln_hv18_snw wmin=2e-005-dxwn_hv18_snw
+ wmax=900.001e-06          version=4.5               binunit=2
+ paramchk=1                mobmod=0                  capmod=2
+ igcmod=0                  igbmod=0                  diomod=1
+ rdsmod=1                  rbodymod=0                rgeomod=1
+ rgatemod=1*rgflag_hv18_snw_spw                      permod=1
+ acnqsmod=0                trnqsmod=0                tempmod=0
+ tnom=25                   toxe=toxn_hv18_snw        toxm=3.58e-009
+ dtox=2.7936e-010          epsrox=3.9                wint=0
+ lint=2.45e-007            ll=0                      wl=0
+ lln=1                     wln=1                     lw=0
+ ww=0                      lwn=1                     wwn=1
+ lwl=0                     wwl=0                     llc=0
+ wlc=0                     lwc=0                     wwc=0
+ lwlc=0                    wwlc=0                    xl=1e-08+dxln_hv18_snw
+ xw=0+dxwn_hv18_snw        dlc=ddlcn_hv18_snw        dwc=0
+ xpart=1                   toxref=3e-009             dlcig=2.5e-009
+ vth0=0.56147024+dvthn_hv18_snw                      lvth0=1.4944688e-008+dlvthn_hv18_snw
+ k1=0.24874                k2=0.060154596+dk2n_hv18_snw
+ lk2=7.7341702e-009+dlk2n_hv18_snw                   k3=-1.82
+ k3b=1.0692                w0=0                      dvt0=1.1319
+ dvt1=0.0055               dvt2=0.00050391           dvt0w=0
+ dvt1w=0                   dvt2w=0                   dsub=0.25
+ minv=-0.4444              lminv=-5.5004411e-015     voffl=-5e-009
+ dvtp0=2.1516e-007         dvtp1=0.01                lpe0=5e-007
+ lpeb=2.4075e-007          xj=6.7e-008               ngate=8.5997e+020
+ ndep=9e+017               nsd=1e+020                phin=0.185
+ cdsc=0                    cdscb=0                   cdscd=0
+ cit=0.00020568264+dcitn_hv18_snw                    lcit=3.6030165e-010+dlcitn_hv18_snw
+ voff=-0.17691751+dvoffn_hv18_snw                    lvoff=2.177629e-008+dlvoffn_hv18_snw
+ nfactor=0.6+dnfactorn_hv18_snw                      eta0=0.0010241+deta0n_hv18_snw
+ etab=-0.053029169         letab=1.0450838e-014      ud=0
+ lud=0                     wud=0                     pud=0
+ u0=0.033674484+du0n_hv18_snw                        lu0=5.1649081e-009+dlu0n_hv18_snw
+ ua=-7.7524923e-010        lua=7.1010794e-017        ub=2.1628173e-018
+ lub=3.8635098e-025        uc=1.048964e-010          luc=8.0669469e-017
+ vsat=159133.34+dvsatn_hv18_snw                      lvsat=0.0082506617+dlvsatn_hv18_snw
+ a0=2.3647754+da0n_hv18_snw-0.0288889*ff_flag_hv18_snw_spw+0.0288889*ss_flag_hv18_snw_spw
+ la0=-1.6600561e-006+dla0n_hv18_snw+2.75022e-07*ff_flag_hv18_snw_spw-2.75022e-07*ss_flag_hv18_snw_spw
+ ags=0.66936746+dagsn_hv18_snw+0.0173333*ff_flag_hv18_snw_spw-0.0173333*ss_flag_hv18_snw_spw
+ lags=-2.4407107e-007+dlagsn_hv18_snw-1.65013e-07*ff_flag_hv18_snw_spw+1.65013e-07*ss_flag_hv18_snw_spw
+ a1=0                      a2=1                      b0=0
+ b1=0                      keta=-0.043430273         lketa=-2.6063298e-008
+ dwg=0                     dwb=0                     pclm=0.014996
+ pdiblc1=0                 pdiblc2=0.0001            pdiblcb=0
+ drout=0.56                pvag=0.45                 delta=0.01
+ pscbe1=9.264e+008         pscbe2=1e-020             fprout=100
+ pdits=0                   pditsd=0                  pditsl=0
+ rsh=17.5                  rsw=65.35                 rdw=600
+ prwg=0                    prwb=0                    wr=1
+ alpha0=6.3669e-08         alpha1=1.5                beta0=29.5
+ agidl=4e-009+dagidln_hv18_snw                       bgidl=8e+009+dbgidln_hv18_snw
+ cgidl=21.599              egidl=0.55661             aigbacc=0.01238
+ bigbacc=0.006109          cigbacc=0.2809            nigbacc=4.05
+ aigbinv=0.02              bigbinv=0.02              cigbinv=0.006
+ eigbinv=1.1               nigbinv=1                 aigc=0.009898
+ bigc=0.001383             cigc=1.515e-005           aigsd=0.0086
+ bigsd=0.0004353           cigsd=3.925e-020          nigc=1
+ poxedge=1                 pigcd=1.672               ntox=1
+ xrcrg1=12                 xrcrg2=1                  cgso=cgson_hv18_snw
+ cgdo=cgdon_hv18_snw       cgbo=0                    cgdl=cgdln_hv18_snw
+ cgsl=cgsln_hv18_snw       clc=1e-007                cle=0.6
+ cf=cfn_hv18_snw           ckappas=0.6               ckappad=0.6
+ acde=0.3                  moin=5.2                  noff=2.9337
+ voffcv=-0.16925           tvoff=0.001               ltvoff=0
+ wtvoff=0                  ptvoff=0                  kt1=-0.18819649+dkt1n_hv18_snw
+ lkt1=-3.5257827e-008+dlkt1n_hv18_snw                kt1l=0
+ kt2=-0.044409832          lkt2=-8.3221674e-009      ute=-1.35
+ ua1=1.3011459e-009        lua1=5.0032012e-016       ub1=-1.6529705e-018
+ lub1=-2.4113939e-025      uc1=1.1246722e-010        luc1=2.0494644e-017
+ prt=0                     at=11555.427+datn_hv18_snw
+ lat=-0.11000882+dlatn_hv18_snw                      jss=5.23e-007
+ jsws=2.52e-013            jswgs=2.52e-013           njs=1.02
+ njd=1.02                  ijthsfwd=0.01             ijthdfwd=0.01
+ ijthsrev=0.01             ijthdrev=0.01             bvs=8.4
+ xjbvs=1                   xjbvd=1                   jsd=1.03e-006
+ jswd=1.14e-012            jswgd=1.14e-012           bvd=14.1
+ jtsswgs=3e-009+djtsswgsn_hv18_snw                   jtsswgd=6e-008+djtsswgdn_hv18_snw
+ njtsswg=20+dnjtsswgn_hv18_snw                       xtsswgs=0.1
+ xtsswgd=0.75              tnjtsswg=0.5              vtsswgs=0.7
+ vtsswgd=0.05              pbs=0.5                   cjs=cjsn_hv18_snw
+ mjs=0.24                  pbsws=0.3                 cjsws=cjswsn_hv18_snw
+ mjsws=0.013               pbswgs=0.5                cjswgs=cjswgsn_hv18_snw
+ mjswgs=0.3                pbd=0.56                  cjd=cjdn_hv18_snw
+ mjd=0.36                  pbswd=0.8                 cjswd=cjswdn_hv18_snw
+ mjswd=0.31                pbswgd=0.8                cjswgd=cjswgdn_hv18_snw
+ mjswgd=0.36               tpb=0.002                 tcj=0.0018
+ tpbsw=0.0025              tcjsw=0.0011              tpbswg=0.0028
+ tcjswg=0.00157            xtis=3                    xtid=3
+ dmcg=6.4e-08              dmci=6.4e-08              dmdg=0
+ dmcgt=0                   dwj=0                     xgw=0
+ xgl=-1.09e-08             rshg=15.6                 gbmin=1e-012
+ rbpb=50                   rbpd=50                   rbps=50
+ rbdb=50                   rbsb=50                   ngcon=1
+ wvth0=0+dwvthn_hv18_snw   pvth0=0+dpvthn_hv18_snw   wu0=0+dwu0n_hv18_snw
+ pu0=0+dpu0n_hv18_snw      wa0=0+dwa0n_hv18_snw+0.0*ff_flag_hv18_snw_spw+0.0*ss_flag_hv18_snw_spw
+ pa0=0+dpa0n_hv18_snw+0.0*ff_flag_hv18_snw_spw+0.0*ss_flag_hv18_snw_spw
+ wags=0+dwagsn_hv18_snw+0.0*ff_flag_hv18_snw_spw+0.0*ss_flag_hv18_snw_spw
+ pags=0+dpagsn_hv18_snw+0.0*ff_flag_hv18_snw_spw+0.0*ss_flag_hv18_snw_spw
+ wnfactor=0+dwnfactorn_hv18_snw                      lnfactor=0+dlnfactorn_hv18_snw
+ pnfactor=0+dpnfactorn_hv18_snw                      pvsat=0+dpvsatn_hv18_snw
+ wvsat=0+dwvsatn_hv18_snw  wk2=0+dwk2n_hv18_snw      pk2=0+dpk2n_hv18_snw
+ weta0=0+dweta0n_hv18_snw  wcit=0+dwcitn_hv18_snw    pcit=0+dpcitn_hv18_snw
+ wvoff=0+dwvoffn_hv18_snw  pvoff=0+dpvoffn_hv18_snw  wkt1=0+dwkt1n_hv18_snw
+ pkt1=0+dpkt1n_hv18_snw    wat=0+dwatn_hv18_snw      pat=0+dpatn_hv18_snw
+ lagidl=0+dlagidln_hv18_snw                          wagidl=0+dwagidln_hv18_snw
+ pagidl=0+dpagidln_hv18_snw                          lbgidl=0+dlbgidln_hv18_snw
+ wbgidl=0+dwbgidln_hv18_snw                          pbgidl=0+dpbgidln_hv18_snw
+ minr=1e-3

     3: type=n
+ lmin=9e-007-dxln_hv18_snw lmax=1e-006-dxln_hv18_snw wmin=2e-005-dxwn_hv18_snw
+ wmax=900.001e-06          version=4.5               binunit=2
+ paramchk=1                mobmod=0                  capmod=2
+ igcmod=0                  igbmod=0                  diomod=1
+ rdsmod=1                  rbodymod=0                rgeomod=1
+ rgatemod=1*rgflag_hv18_snw_spw                      permod=1
+ acnqsmod=0                trnqsmod=0                tempmod=0
+ tnom=25                   toxe=toxn_hv18_snw        toxm=3.58e-009
+ dtox=2.7936e-010          epsrox=3.9                wint=0
+ lint=2.45e-007            ll=0                      wl=0
+ lln=1                     wln=1                     lw=0
+ ww=0                      lwn=1                     wwn=1
+ lwl=0                     wwl=0                     llc=0
+ wlc=0                     lwc=0                     wwc=0
+ lwlc=0                    wwlc=0                    xl=1e-08+dxln_hv18_snw
+ xw=0+dxwn_hv18_snw        dlc=ddlcn_hv18_snw        dwc=0
+ xpart=1                   toxref=3e-009             dlcig=2.5e-009
+ vth0=0.5085201+dvthn_hv18_snw                       lvth0=4.2478756e-008+dlvthn_hv18_snw
+ k1=0.24874                k2=0.0863806+dk2n_hv18_snw
+ lk2=-5.903352e-009+dlk2n_hv18_snw                   k3=-1.82
+ k3b=1.0692                w0=0                      dvt0=1.1319
+ dvt1=0.0055               dvt2=0.00050391           dvt0w=0
+ dvt1w=0                   dvt2w=0                   dsub=0.25
+ minv=-0.44440005          lminv=2.184e-014          voffl=-5e-009
+ dvtp0=2.1516e-007         dvtp1=0.01                lpe0=5e-007
+ lpeb=2.4075e-007          xj=6.7e-008               ngate=8.5997e+020
+ ndep=9e+017               nsd=1e+020                phin=0.185
+ cdsc=0                    cdscb=0                   cdscd=0
+ cit=0.00050797245+dcitn_hv18_snw                    lcit=2.0311095e-010+dlcitn_hv18_snw
+ voff=-0.13823216+dvoffn_hv18_snw                    lvoff=1.6599055e-009+dlvoffn_hv18_snw
+ nfactor=0.6+dnfactorn_hv18_snw                      eta0=0.0010241+deta0n_hv18_snw
+ etab=-0.053029149         ud=0                      lud=0
+ wud=0                     pud=0                     u0=0.045602+du0n_hv18_snw
+ lu0=-1.0374e-009+dlu0n_hv18_snw                     ua=-2.0877822e-010
+ lua=-2.2355413e-016       ub=2.18382e-018           lub=3.754296e-025
+ uc=3.15008e-010           luc=-2.858856e-017        vsat=238000+dvsatn_hv18_snw
+ lvsat=-0.03276+dlvsatn_hv18_snw                     a0=1.3608114+da0n_hv18_snw+1.34*ff_flag_hv18_snw_spw-1.34*ss_flag_hv18_snw_spw
+ la0=-1.1379948e-006+dla0n_hv18_snw-4.368e-07*ff_flag_hv18_snw_spw+4.368e-07*ss_flag_hv18_snw_spw
+ ags=-0.20618262+dagsn_hv18_snw-1.56*ff_flag_hv18_snw_spw+1.14*ss_flag_hv18_snw_spw
+ lags=2.1121497e-007+dlagsn_hv18_snw+6.552e-07*ff_flag_hv18_snw_spw-4.368e-07*ss_flag_hv18_snw_spw
+ a1=0                      a2=1                      b0=0
+ b1=0                      keta=-0.079965021         lketa=-7.0652291e-009
+ dwg=0                     dwb=0                     pclm=0.014996
+ pdiblc1=0                 pdiblc2=0.0001            pdiblcb=0
+ drout=0.56                pvag=0.45                 delta=0.01
+ pscbe1=9.264e+008         pscbe2=1e-020             fprout=100
+ pdits=0                   pditsd=0                  pditsl=0
+ rsh=17.5                  rsw=65.35                 rdw=600
+ prwg=0                    prwb=0                    wr=1
+ alpha0=6.3669e-08         alpha1=1.5                beta0=29.5
+ agidl=4e-009+dagidln_hv18_snw                       bgidl=8e+009+dbgidln_hv18_snw
+ cgidl=21.599              egidl=0.55661             aigbacc=0.01238
+ bigbacc=0.006109          cigbacc=0.2809            nigbacc=4.05
+ aigbinv=0.02              bigbinv=0.02              cigbinv=0.006
+ eigbinv=1.1               nigbinv=1                 aigc=0.009898
+ bigc=0.001383             cigc=1.515e-005           aigsd=0.0086
+ bigsd=0.0004353           cigsd=3.925e-020          nigc=1
+ poxedge=1                 pigcd=1.672               ntox=1
+ xrcrg1=12                 xrcrg2=1                  cgso=cgson_hv18_snw
+ cgdo=cgdon_hv18_snw       cgbo=0                    cgdl=cgdln_hv18_snw
+ cgsl=cgsln_hv18_snw       clc=1e-007                cle=0.6
+ cf=cfn_hv18_snw           ckappas=0.6               ckappad=0.6
+ acde=0.3                  moin=5.2                  noff=2.9337
+ voffcv=-0.16925           tvoff=0.001               ltvoff=0
+ wtvoff=0                  ptvoff=0                  kt1=-0.255496+dkt1n_hv18_snw
+ lkt1=-2.6208e-010+dlkt1n_hv18_snw                   kt1l=0
+ kt2=-0.0990456            lkt2=2.0088432e-008       ute=-1.35
+ ua1=2.32882e-009          lua1=-3.40704e-017        ub1=-2.9386405e-018
+ lub1=4.2740902e-025       uc1=8.0942042e-011        luc1=3.6887738e-017
+ prt=0                     at=-200000+datn_hv18_snw  jss=5.23e-007
+ jsws=2.52e-013            jswgs=2.52e-013           njs=1.02
+ njd=1.02                  ijthsfwd=0.01             ijthdfwd=0.01
+ ijthsrev=0.01             ijthdrev=0.01             bvs=8.4
+ xjbvs=1                   xjbvd=1                   jsd=1.03e-006
+ jswd=1.14e-012            jswgd=1.14e-012           bvd=14.1
+ jtsswgs=3e-009+djtsswgsn_hv18_snw                   jtsswgd=6e-008+djtsswgdn_hv18_snw
+ njtsswg=20+dnjtsswgn_hv18_snw                       xtsswgs=0.1
+ xtsswgd=0.75              tnjtsswg=0.5              vtsswgs=0.7
+ vtsswgd=0.05              pbs=0.5                   cjs=cjsn_hv18_snw
+ mjs=0.24                  pbsws=0.3                 cjsws=cjswsn_hv18_snw
+ mjsws=0.013               pbswgs=0.5                cjswgs=cjswgsn_hv18_snw
+ mjswgs=0.3                pbd=0.56                  cjd=cjdn_hv18_snw
+ mjd=0.36                  pbswd=0.8                 cjswd=cjswdn_hv18_snw
+ mjswd=0.31                pbswgd=0.8                cjswgd=cjswgdn_hv18_snw
+ mjswgd=0.36               tpb=0.002                 tcj=0.0018
+ tpbsw=0.0025              tcjsw=0.0011              tpbswg=0.0028
+ tcjswg=0.00157            xtis=3                    xtid=3
+ dmcg=6.4e-08              dmci=6.4e-08              dmdg=0
+ dmcgt=0                   dwj=0                     xgw=0
+ xgl=-1.09e-08             rshg=15.6                 gbmin=1e-012
+ rbpb=50                   rbpd=50                   rbps=50
+ rbdb=50                   rbsb=50                   ngcon=1
+ wvth0=0+dwvthn_hv18_snw   pvth0=0+dpvthn_hv18_snw   wu0=0+dwu0n_hv18_snw
+ pu0=0+dpu0n_hv18_snw      wa0=0+dwa0n_hv18_snw+0.0*ff_flag_hv18_snw_spw+0.0*ss_flag_hv18_snw_spw
+ pa0=0+dpa0n_hv18_snw+0.0*ff_flag_hv18_snw_spw+0.0*ss_flag_hv18_snw_spw
+ wags=0+dwagsn_hv18_snw+0.0*ff_flag_hv18_snw_spw+0.0*ss_flag_hv18_snw_spw
+ pags=0+dpagsn_hv18_snw+0.0*ff_flag_hv18_snw_spw+0.0*ss_flag_hv18_snw_spw
+ wnfactor=0+dwnfactorn_hv18_snw                      lnfactor=0+dlnfactorn_hv18_snw
+ pnfactor=0+dpnfactorn_hv18_snw                      pvsat=0+dpvsatn_hv18_snw
+ wvsat=0+dwvsatn_hv18_snw  wk2=0+dwk2n_hv18_snw      pk2=0+dpk2n_hv18_snw
+ weta0=0+dweta0n_hv18_snw  wcit=0+dwcitn_hv18_snw    pcit=0+dpcitn_hv18_snw
+ wvoff=0+dwvoffn_hv18_snw  pvoff=0+dpvoffn_hv18_snw  wkt1=0+dwkt1n_hv18_snw
+ pkt1=0+dpkt1n_hv18_snw    lat=0+dlatn_hv18_snw      wat=0+dwatn_hv18_snw
+ pat=0+dpatn_hv18_snw      lagidl=0+dlagidln_hv18_snw
+ wagidl=0+dwagidln_hv18_snw                          pagidl=0+dpagidln_hv18_snw
+ lbgidl=0+dlbgidln_hv18_snw                          wbgidl=0+dwbgidln_hv18_snw
+ pbgidl=0+dpbgidln_hv18_snw                          minr=1e-3

     4: type=n
+ lmin=8.5e-007-dxln_hv18_snw                         lmax=9e-007-dxln_hv18_snw
+ wmin=2e-005-dxwn_hv18_snw wmax=900.001e-06          version=4.5
+ binunit=2                 paramchk=1                mobmod=0
+ capmod=2                  igcmod=0                  igbmod=0
+ diomod=1                  rdsmod=1                  rbodymod=0
+ rgeomod=1                 rgatemod=1*rgflag_hv18_snw_spw
+ permod=1                  acnqsmod=0                trnqsmod=0
+ tempmod=0                 tnom=25                   toxe=toxn_hv18_snw
+ toxm=3.58e-009            dtox=2.7936e-010          epsrox=3.9
+ wint=0                    lint=2.45e-007            ll=0
+ wl=0                      lln=1                     wln=1
+ lw=0                      ww=0                      lwn=1
+ wwn=1                     lwl=0                     wwl=0
+ llc=0                     wlc=0                     lwc=0
+ wwc=0                     lwlc=0                    wwlc=0
+ xl=1e-08+dxln_hv18_snw    xw=0+dxwn_hv18_snw        dlc=ddlcn_hv18_snw
+ dwc=0                     xpart=1                   toxref=3e-009
+ dlcig=2.5e-009            vth0=0.582058+dvthn_hv18_snw
+ lvth0=1.159284e-008+dlvthn_hv18_snw                 k1=0.24874
+ k2=0.1004746+dk2n_hv18_snw                          lk2=-1.1822832e-008+dlk2n_hv18_snw
+ k3=-1.82                  k3b=1.0692                w0=0
+ dvt0=1.1319               dvt1=0.0055               dvt2=0.00050391
+ dvt0w=0                   dvt1w=0                   dvt2w=0
+ dsub=0.25                 minv=-0.4444              voffl=-5e-009
+ dvtp0=2.1516e-007         dvtp1=0.01                lpe0=5e-007
+ lpeb=2.4075e-007          xj=6.7e-008               ngate=8.5997e+020
+ ndep=9e+017               nsd=1e+020                phin=0.185
+ cdsc=0                    cdscb=0                   cdscd=0
+ cit=0.0016332236+dcitn_hv18_snw                     lcit=-2.6949452e-010+dlcitn_hv18_snw
+ voff=-0.140126+dvoffn_hv18_snw                      lvoff=2.45532e-009+dlvoffn_hv18_snw
+ nfactor=0.6+dnfactorn_hv18_snw                      eta0=0.0010241+deta0n_hv18_snw
+ etab=-0.053029149         ud=0                      lud=0
+ wud=0                     pud=0                     u0=0.0500066+du0n_hv18_snw
+ lu0=-2.887332e-009+dlu0n_hv18_snw                   ua=-1.4409181e-010
+ lua=-2.5072242e-016       ub=2.8016793e-018         lub=1.1592871e-025
+ uc=4.7219607e-010         luc=-9.4607551e-017       vsat=160000+dvsatn_hv18_snw
+ a0=2.07898+da0n_hv18_snw-0.44*ff_flag_hv18_snw_spw-0.3*ss_flag_hv18_snw_spw
+ la0=-1.4396256e-006+dla0n_hv18_snw+3.108e-07*ff_flag_hv18_snw_spw+0.0*ss_flag_hv18_snw_spw
+ ags=-1.6997347+dagsn_hv18_snw+0.0*ff_flag_hv18_snw_spw+0.1*ss_flag_hv18_snw_spw
+ lags=8.3850685e-007+dlagsn_hv18_snw+0.0*ff_flag_hv18_snw_spw+0.0*ss_flag_hv18_snw_spw
+ a1=0                      a2=1                      b0=0
+ b1=0                      keta=-0.24838339          lketa=6.3670485e-008
+ dwg=0                     dwb=0                     pclm=0.0149664
+ lpclm=1.2432e-011         pdiblc1=0                 pdiblc2=0.00010000018
+ lpdiblc2=-7.4591999e-017  pdiblcb=0                 drout=0.56
+ pvag=0.45                 delta=0.01                pscbe1=9.264e+008
+ pscbe2=1e-020             fprout=100                pdits=0
+ pditsd=0                  pditsl=0                  rsh=17.5
+ rsw=65.35                 rdw=600                   prwg=0
+ prwb=0                    wr=1                      alpha0=6.3669e-08
+ alpha1=1.5                beta0=29.5                agidl=4e-009+dagidln_hv18_snw
+ bgidl=8e+009+dbgidln_hv18_snw                       cgidl=21.599
+ egidl=0.55661             aigbacc=0.01238           bigbacc=0.006109
+ cigbacc=0.2809            nigbacc=4.05              aigbinv=0.02
+ bigbinv=0.02              cigbinv=0.006             eigbinv=1.1
+ nigbinv=1                 aigc=0.009898             bigc=0.001383
+ cigc=1.515e-005           aigsd=0.0086              bigsd=0.0004353
+ cigsd=3.925e-020          nigc=1                    poxedge=1
+ pigcd=1.672               ntox=1                    xrcrg1=12
+ xrcrg2=1                  cgso=cgson_hv18_snw       cgdo=cgdon_hv18_snw
+ cgbo=0                    cgdl=cgdln_hv18_snw       cgsl=cgsln_hv18_snw
+ clc=1e-007                cle=0.6                   cf=cfn_hv18_snw
+ ckappas=0.6               ckappad=0.6               acde=0.3
+ moin=5.2                  noff=2.9337               voffcv=-0.16925
+ tvoff=0.001               ltvoff=0                  wtvoff=0
+ ptvoff=0                  kt1=-0.257008+dkt1n_hv18_snw
+ lkt1=3.7296e-010+dlkt1n_hv18_snw                    kt1l=0
+ kt2=-0.041744             lkt2=-3.97824e-009        ute=-1.35
+ ua1=2.8863185e-009        lua1=-2.6821978e-016      ub1=-4.40296e-018
+ lub1=1.0424232e-024       uc1=1.3391584e-010        luc1=1.4638742e-017
+ prt=0                     at=-200000+datn_hv18_snw  jss=5.23e-007
+ jsws=2.52e-013            jswgs=2.52e-013           njs=1.02
+ njd=1.02                  ijthsfwd=0.01             ijthdfwd=0.01
+ ijthsrev=0.01             ijthdrev=0.01             bvs=8.4
+ xjbvs=1                   xjbvd=1                   jsd=1.03e-006
+ jswd=1.14e-012            jswgd=1.14e-012           bvd=14.1
+ jtsswgs=3e-009+djtsswgsn_hv18_snw                   jtsswgd=6e-008+djtsswgdn_hv18_snw
+ njtsswg=20+dnjtsswgn_hv18_snw                       xtsswgs=0.1
+ xtsswgd=0.75              tnjtsswg=0.5              vtsswgs=0.7
+ vtsswgd=0.05              pbs=0.5                   cjs=cjsn_hv18_snw
+ mjs=0.24                  pbsws=0.3                 cjsws=cjswsn_hv18_snw
+ mjsws=0.013               pbswgs=0.5                cjswgs=cjswgsn_hv18_snw
+ mjswgs=0.3                pbd=0.56                  cjd=cjdn_hv18_snw
+ mjd=0.36                  pbswd=0.8                 cjswd=cjswdn_hv18_snw
+ mjswd=0.31                pbswgd=0.8                cjswgd=cjswgdn_hv18_snw
+ mjswgd=0.36               tpb=0.002                 tcj=0.0018
+ tpbsw=0.0025              tcjsw=0.0011              tpbswg=0.0028
+ tcjswg=0.00157            xtis=3                    xtid=3
+ dmcg=6.4e-08              dmci=6.4e-08              dmdg=0
+ dmcgt=0                   dwj=0                     xgw=0
+ xgl=-1.09e-08             rshg=15.6                 gbmin=1e-012
+ rbpb=50                   rbpd=50                   rbps=50
+ rbdb=50                   rbsb=50                   ngcon=1
+ wvth0=0+dwvthn_hv18_snw   pvth0=0+dpvthn_hv18_snw   wu0=0+dwu0n_hv18_snw
+ pu0=0+dpu0n_hv18_snw      wa0=0+dwa0n_hv18_snw+0.0*ff_flag_hv18_snw_spw+0.0*ss_flag_hv18_snw_spw
+ pa0=0+dpa0n_hv18_snw+0.0*ff_flag_hv18_snw_spw+0.0*ss_flag_hv18_snw_spw
+ wags=0+dwagsn_hv18_snw+0.0*ff_flag_hv18_snw_spw+0.0*ss_flag_hv18_snw_spw
+ pags=0+dpagsn_hv18_snw+0.0*ff_flag_hv18_snw_spw+0.0*ss_flag_hv18_snw_spw
+ lvsat=0+dlvsatn_hv18_snw  wnfactor=0+dwnfactorn_hv18_snw
+ lnfactor=0+dlnfactorn_hv18_snw                      pnfactor=0+dpnfactorn_hv18_snw
+ pvsat=0+dpvsatn_hv18_snw  wvsat=0+dwvsatn_hv18_snw  wk2=0+dwk2n_hv18_snw
+ pk2=0+dpk2n_hv18_snw      weta0=0+dweta0n_hv18_snw  wcit=0+dwcitn_hv18_snw
+ pcit=0+dpcitn_hv18_snw    wvoff=0+dwvoffn_hv18_snw  pvoff=0+dpvoffn_hv18_snw
+ wkt1=0+dwkt1n_hv18_snw    pkt1=0+dpkt1n_hv18_snw    lat=0+dlatn_hv18_snw
+ wat=0+dwatn_hv18_snw      pat=0+dpatn_hv18_snw      lagidl=0+dlagidln_hv18_snw
+ wagidl=0+dwagidln_hv18_snw                          pagidl=0+dpagidln_hv18_snw
+ lbgidl=0+dlbgidln_hv18_snw                          wbgidl=0+dwbgidln_hv18_snw
+ pbgidl=0+dpbgidln_hv18_snw                          minr=1e-3

     5: type=n
+ lmin=0.792e-06            lmax=8.5e-007-dxln_hv18_snw
+ wmin=2e-005-dxwn_hv18_snw wmax=900.001e-06          version=4.5
+ binunit=2                 paramchk=1                mobmod=0
+ capmod=2                  igcmod=0                  igbmod=0
+ diomod=1                  rdsmod=1                  rbodymod=0
+ rgeomod=1                 rgatemod=1*rgflag_hv18_snw_spw
+ permod=1                  acnqsmod=0                trnqsmod=0
+ tempmod=0                 tnom=25                   toxe=toxn_hv18_snw
+ toxm=3.58e-009            dtox=2.7936e-010          epsrox=3.9
+ wint=0                    lint=2.45e-007            ll=0
+ wl=0                      lln=1                     wln=1
+ lw=0                      ww=0                      lwn=1
+ wwn=1                     lwl=0                     wwl=0
+ llc=0                     wlc=0                     lwc=0
+ wwc=0                     lwlc=0                    wwlc=0
+ xl=1e-08+dxln_hv18_snw    xw=0+dxwn_hv18_snw        dlc=ddlcn_hv18_snw
+ dwc=0                     xpart=1                   toxref=3e-009
+ dlcig=2.5e-009            vth0=0.694222+dvthn_hv18_snw
+ lvth0=-2.990784e-008+dlvthn_hv18_snw                k1=0.24874
+ k2=0.1274138+dk2n_hv18_snw                          lk2=-2.1790336e-008+dlk2n_hv18_snw
+ k3=-1.82                  k3b=1.0692                w0=0
+ dvt0=1.1319               dvt1=0.0055               dvt2=0.00050391
+ dvt0w=0                   dvt1w=0                   dvt2w=0
+ dsub=0.25                 minv=-0.43928             lminv=-1.8944e-009
+ voffl=-5e-009             dvtp0=2.1516e-007         dvtp1=0.01
+ lpe0=5e-007               lpeb=2.4075e-007          xj=6.7e-008
+ ngate=8.5997e+020         ndep=9e+017               nsd=1e+020
+ phin=0.185                cdsc=0                    cdscb=0
+ cdscd=0                   cit=0.00101174+dcitn_hv18_snw
+ lcit=-3.95456e-011+dlcitn_hv18_snw                  voff=-0.190834+dvoffn_hv18_snw
+ lvoff=2.121728e-008+dlvoffn_hv18_snw                nfactor=0.6+dnfactorn_hv18_snw
+ eta0=0.0010241+deta0n_hv18_snw                      etab=-0.053029149
+ ud=0                      lud=0                     wud=0
+ pud=0                     u0=0.0308942+du0n_hv18_snw
+ lu0=4.184256e-009+dlu0n_hv18_snw                    ua=-1.776216e-009
+ lua=3.5316352e-016        ub=2.1012401e-018         lub=3.750912e-025
+ uc=5.6465999e-010         luc=-1.288192e-016        vsat=160000+dvsatn_hv18_snw
+ a0=1.49754+da0n_hv18_snw+2.96*ff_flag_hv18_snw_spw-2.22*ss_flag_hv18_snw_spw
+ la0=-1.2244928e-006+dla0n_hv18_snw-9.472e-07*ff_flag_hv18_snw_spw+7.104e-07*ss_flag_hv18_snw_spw
+ ags=-1.000348+dagsn_hv18_snw+0.0*ff_flag_hv18_snw_spw+0.74*ss_flag_hv18_snw_spw
+ lags=5.7973376e-007+dlagsn_hv18_snw+0.0*ff_flag_hv18_snw_spw-2.368e-07*ss_flag_hv18_snw_spw
+ a1=0                      a2=1                      b0=0
+ b1=0                      keta=-0.164877            lketa=3.277312e-008
+ dwg=0                     dwb=0                     pclm=-0.0489744
+ lpclm=2.3670528e-008      pdiblc1=0                 pdiblc2=-0.00118
+ lpdiblc2=4.7359999e-010   pdiblcb=0                 drout=0.56
+ pvag=0.45                 delta=0.01                pscbe1=9.264e+008
+ pscbe2=1e-020             fprout=100                pdits=0
+ pditsd=0                  pditsl=0                  rsh=17.5
+ rsw=65.35                 rdw=600                   prwg=0
+ prwb=0                    wr=1                      alpha0=6.3669e-08
+ alpha1=1.5                beta0=29.5                agidl=4e-009+dagidln_hv18_snw
+ bgidl=8e+009+dbgidln_hv18_snw                       cgidl=21.599
+ egidl=0.55661             aigbacc=0.01238           bigbacc=0.006109
+ cigbacc=0.2809            nigbacc=4.05              aigbinv=0.02
+ bigbinv=0.02              cigbinv=0.006             eigbinv=1.1
+ nigbinv=1                 aigc=0.009898             bigc=0.001383
+ cigc=1.515e-005           aigsd=0.0086              bigsd=0.0004353
+ cigsd=3.925e-020          nigc=1                    poxedge=1
+ pigcd=1.672               ntox=1                    xrcrg1=12
+ xrcrg2=1                  cgso=cgson_hv18_snw       cgdo=cgdon_hv18_snw
+ cgbo=0                    cgdl=cgdln_hv18_snw       cgsl=cgsln_hv18_snw
+ clc=1e-007                cle=0.6                   cf=cfn_hv18_snw
+ ckappas=0.6               ckappad=0.6               acde=0.3
+ moin=5.2                  noff=2.9337               voffcv=-0.16925
+ tvoff=0.001               ltvoff=0                  wtvoff=0
+ ptvoff=0                  kt1=-0.25184+dkt1n_hv18_snw
+ lkt1=-1.5392e-009+dlkt1n_hv18_snw                   kt1l=0
+ kt2=-0.0422112            lkt2=-3.805376e-009       ute=-1.35
+ ua1=-3.2453198e-009       lua1=2.0004864e-015       ub1=6.04e-018
+ lub1=-2.821472e-024       uc1=4.3242401e-010        luc1=-9.580928e-017
+ prt=0                     at=-200000+datn_hv18_snw  jss=5.23e-007
+ jsws=2.52e-013            jswgs=2.52e-013           njs=1.02
+ njd=1.02                  ijthsfwd=0.01             ijthdfwd=0.01
+ ijthsrev=0.01             ijthdrev=0.01             bvs=8.4
+ xjbvs=1                   xjbvd=1                   jsd=1.03e-006
+ jswd=1.14e-012            jswgd=1.14e-012           bvd=14.1
+ jtsswgs=3e-009+djtsswgsn_hv18_snw                   jtsswgd=6e-008+djtsswgdn_hv18_snw
+ njtsswg=20+dnjtsswgn_hv18_snw                       xtsswgs=0.1
+ xtsswgd=0.75              tnjtsswg=0.5              vtsswgs=0.7
+ vtsswgd=0.05              pbs=0.5                   cjs=cjsn_hv18_snw
+ mjs=0.24                  pbsws=0.3                 cjsws=cjswsn_hv18_snw
+ mjsws=0.013               pbswgs=0.5                cjswgs=cjswgsn_hv18_snw
+ mjswgs=0.3                pbd=0.56                  cjd=cjdn_hv18_snw
+ mjd=0.36                  pbswd=0.8                 cjswd=cjswdn_hv18_snw
+ mjswd=0.31                pbswgd=0.8                cjswgd=cjswgdn_hv18_snw
+ mjswgd=0.36               tpb=0.002                 tcj=0.0018
+ tpbsw=0.0025              tcjsw=0.0011              tpbswg=0.0028
+ tcjswg=0.00157            xtis=3                    xtid=3
+ dmcg=6.4e-08              dmci=6.4e-08              dmdg=0
+ dmcgt=0                   dwj=0                     xgw=0
+ xgl=-1.09e-08             rshg=15.6                 gbmin=1e-012
+ rbpb=50                   rbpd=50                   rbps=50
+ rbdb=50                   rbsb=50                   ngcon=1
+ wvth0=0+dwvthn_hv18_snw   pvth0=0+dpvthn_hv18_snw   wu0=0+dwu0n_hv18_snw
+ pu0=0+dpu0n_hv18_snw      wa0=0+dwa0n_hv18_snw+0.0*ff_flag_hv18_snw_spw+0.0*ss_flag_hv18_snw_spw
+ pa0=0+dpa0n_hv18_snw+0.0*ff_flag_hv18_snw_spw+0.0*ss_flag_hv18_snw_spw
+ wags=0+dwagsn_hv18_snw+0.0*ff_flag_hv18_snw_spw+0.0*ss_flag_hv18_snw_spw
+ pags=0+dpagsn_hv18_snw+0.0*ff_flag_hv18_snw_spw+0.0*ss_flag_hv18_snw_spw
+ lvsat=0+dlvsatn_hv18_snw  wnfactor=0+dwnfactorn_hv18_snw
+ lnfactor=0+dlnfactorn_hv18_snw                      pnfactor=0+dpnfactorn_hv18_snw
+ pvsat=0+dpvsatn_hv18_snw  wvsat=0+dwvsatn_hv18_snw  wk2=0+dwk2n_hv18_snw
+ pk2=0+dpk2n_hv18_snw      weta0=0+dweta0n_hv18_snw  wcit=0+dwcitn_hv18_snw
+ pcit=0+dpcitn_hv18_snw    wvoff=0+dwvoffn_hv18_snw  pvoff=0+dpvoffn_hv18_snw
+ wkt1=0+dwkt1n_hv18_snw    pkt1=0+dpkt1n_hv18_snw    lat=0+dlatn_hv18_snw
+ wat=0+dwatn_hv18_snw      pat=0+dpatn_hv18_snw      lagidl=0+dlagidln_hv18_snw
+ wagidl=0+dwagidln_hv18_snw                          pagidl=0+dpagidln_hv18_snw
+ lbgidl=0+dlbgidln_hv18_snw                          wbgidl=0+dwbgidln_hv18_snw
+ pbgidl=0+dpbgidln_hv18_snw                          minr=1e-3

     6: type=n
+ lmin=1e-005-dxln_hv18_snw lmax=900.001e-06          wmin=1e-005-dxwn_hv18_snw
+ wmax=2e-005-dxwn_hv18_snw version=4.5               binunit=2
+ paramchk=1                mobmod=0                  capmod=2
+ igcmod=0                  igbmod=0                  diomod=1
+ rdsmod=1                  rbodymod=0                rgeomod=1
+ rgatemod=1*rgflag_hv18_snw_spw                      permod=1
+ acnqsmod=0                trnqsmod=0                tempmod=0
+ tnom=25                   toxe=toxn_hv18_snw        toxm=3.58e-009
+ dtox=2.7936e-010          epsrox=3.9                wint=0
+ lint=2.45e-007            ll=0                      wl=0
+ lln=1                     wln=1                     lw=0
+ ww=0                      lwn=1                     wwn=1
+ lwl=0                     wwl=0                     llc=0
+ wlc=0                     lwc=0                     wwc=0
+ lwlc=0                    wwlc=0                    xl=1e-08+dxln_hv18_snw
+ xw=0+dxwn_hv18_snw        dlc=ddlcn_hv18_snw        dwc=0
+ xpart=1                   toxref=3e-009             dlcig=2.5e-009
+ vth0=0.57029004+dvthn_hv18_snw                      wvth0=-1.4500068e-007+dwvthn_hv18_snw
+ k1=0.24874                k2=0.057485036+dk2n_hv18_snw
+ wk2=6.9639632e-008+dwk2n_hv18_snw                   k3=-1.82
+ k3b=1.0692                w0=0                      dvt0=1.1319
+ dvt1=0.0055               dvt2=0.00050391           dvt0w=0
+ dvt1w=0                   dvt2w=0                   dsub=0.25
+ minv=-0.4444              voffl=-5e-009             dvtp0=2.1516e-007
+ dvtp1=0.01                lpe0=5e-007               lpeb=2.4075e-007
+ xj=6.7e-008               ngate=8.5997e+020         ndep=9e+017
+ nsd=1e+020                phin=0.185                cdsc=0
+ cdscb=0                   cdscd=0                   cit=0.00013411945+dcitn_hv18_snw
+ wcit=2.1882029e-009+dwcitn_hv18_snw                 voff=-0.18715007+dvoffn_hv18_snw
+ wvoff=2.5040055e-007+dwvoffn_hv18_snw               nfactor=0.6+dnfactorn_hv18_snw
+ eta0=0.0010241+deta0n_hv18_snw                      etab=-0.086615718
+ wetab=6.7173436e-007      ud=0                      lud=0
+ wud=0                     pud=0                     u0=0.03666+du0n_hv18_snw
+ wu0=-4.8860016e-008+dwu0n_hv18_snw                  ua=-8.1663996e-010
+ wua=9.7700032e-016        ub=2.4261978e-018         wub=-4.4559777e-024
+ uc=1.1982994e-010         wuc=-1.2919935e-016       vsat=160000+dvsatn_hv18_snw
+ a0=2.4471988+da0n_hv18_snw                          wa0=-5.1359703e-006+dwa0n_hv18_snw
+ ags=0.64928995+dagsn_hv18_snw                       wags=-1.1119944e-007+dwagsn_hv18_snw
+ a1=0                      a2=1                      b0=0
+ b1=0                      keta=-0.039192042         wketa=-1.3951958e-007
+ dwg=0                     dwb=0                     pclm=0.014996
+ pdiblc1=0                 pdiblc2=0.0001            pdiblcb=0
+ drout=0.56                pvag=0.45                 delta=0.01
+ pscbe1=9.264e+008         pscbe2=1e-020             fprout=100
+ pdits=0                   pditsd=0                  pditsl=0
+ rsh=17.5                  rsw=65.35                 rdw=600
+ prwg=0                    prwb=0                    wr=1
+ alpha0=6.3669e-08         alpha1=1.5                beta0=29.5
+ agidl=4e-009+dagidln_hv18_snw                       bgidl=8e+009+dbgidln_hv18_snw
+ cgidl=21.599              egidl=0.55661             aigbacc=0.01238
+ bigbacc=0.006109          cigbacc=0.2809            nigbacc=4.05
+ aigbinv=0.02              bigbinv=0.02              cigbinv=0.006
+ eigbinv=1.1               nigbinv=1                 aigc=0.009898
+ bigc=0.001383             cigc=1.515e-005           aigsd=0.0086
+ bigsd=0.0004353           cigsd=3.925e-020          nigc=1
+ poxedge=1                 pigcd=1.672               ntox=1
+ xrcrg1=12                 xrcrg2=1                  cgso=cgson_hv18_snw
+ cgdo=cgdon_hv18_snw       cgbo=0                    cgdl=cgdln_hv18_snw
+ cgsl=cgsln_hv18_snw       clc=1e-007                cle=0.6
+ cf=cfn_hv18_snw           ckappas=0.6               ckappad=0.6
+ acde=0.3                  moin=5.2                  noff=2.9337
+ voffcv=-0.16925           tvoff=0.001               ltvoff=0
+ wtvoff=0                  ptvoff=0                  kt1=-0.18288009+dkt1n_hv18_snw
+ wkt1=-1.803991e-007+dwkt1n_hv18_snw                 kt1l=0
+ kt2=-0.041421039          wkt2=-7.7259614e-008      ute=-1.35
+ ua1=2.0433731e-009        wua1=-1.3793531e-014      ub1=-2.7266095e-018
+ wub1=2.0966295e-023       uc1=8.5060296e-011        wuc1=5.9119704e-016
+ prt=0                     at=6.1207342e-005+datn_hv18_snw
+ jss=5.23e-007             jsws=2.52e-013            jswgs=2.52e-013
+ njs=1.02                  njd=1.02                  ijthsfwd=0.01
+ ijthdfwd=0.01             ijthsrev=0.01             ijthdrev=0.01
+ bvs=8.4                   xjbvs=1                   xjbvd=1
+ jsd=1.03e-006             jswd=1.14e-012            jswgd=1.14e-012
+ bvd=14.1                  jtsswgs=3e-009+djtsswgsn_hv18_snw
+ jtsswgd=6e-008+djtsswgdn_hv18_snw                   njtsswg=20+dnjtsswgn_hv18_snw
+ xtsswgs=0.1               xtsswgd=0.75              tnjtsswg=0.5
+ vtsswgs=0.7               vtsswgd=0.05              pbs=0.5
+ cjs=cjsn_hv18_snw         mjs=0.24                  pbsws=0.3
+ cjsws=cjswsn_hv18_snw     mjsws=0.013               pbswgs=0.5
+ cjswgs=cjswgsn_hv18_snw   mjswgs=0.3                pbd=0.56
+ cjd=cjdn_hv18_snw         mjd=0.36                  pbswd=0.8
+ cjswd=cjswdn_hv18_snw     mjswd=0.31                pbswgd=0.8
+ cjswgd=cjswgdn_hv18_snw   mjswgd=0.36               tpb=0.002
+ tcj=0.0018                tpbsw=0.0025              tcjsw=0.0011
+ tpbswg=0.0028             tcjswg=0.00157            xtis=3
+ xtid=3                    dmcg=6.4e-08              dmci=6.4e-08
+ dmdg=0                    dmcgt=0                   dwj=0
+ xgw=0                     xgl=-1.09e-08             rshg=15.6
+ gbmin=1e-012              rbpb=50                   rbpd=50
+ rbps=50                   rbdb=50                   rbsb=50
+ ngcon=1                   lvth0=0+dlvthn_hv18_snw   pvth0=0+dpvthn_hv18_snw
+ lu0=0+dlu0n_hv18_snw      pu0=0+dpu0n_hv18_snw      la0=0+dla0n_hv18_snw
+ pa0=0+dpa0n_hv18_snw      lags=0+dlagsn_hv18_snw    pags=0+dpagsn_hv18_snw
+ lvsat=0+dlvsatn_hv18_snw  wnfactor=0+dwnfactorn_hv18_snw
+ lnfactor=0+dlnfactorn_hv18_snw                      pnfactor=0+dpnfactorn_hv18_snw
+ pvsat=0+dpvsatn_hv18_snw  wvsat=0+dwvsatn_hv18_snw  lk2=0+dlk2n_hv18_snw
+ pk2=0+dpk2n_hv18_snw      weta0=0+dweta0n_hv18_snw  lcit=0+dlcitn_hv18_snw
+ pcit=0+dpcitn_hv18_snw    lvoff=0+dlvoffn_hv18_snw  pvoff=0+dpvoffn_hv18_snw
+ lkt1=0+dlkt1n_hv18_snw    pkt1=0+dpkt1n_hv18_snw    lat=0+dlatn_hv18_snw
+ wat=0+dwatn_hv18_snw      pat=0+dpatn_hv18_snw      lagidl=0+dlagidln_hv18_snw
+ wagidl=0+dwagidln_hv18_snw                          pagidl=0+dpagidln_hv18_snw
+ lbgidl=0+dlbgidln_hv18_snw                          wbgidl=0+dwbgidln_hv18_snw
+ pbgidl=0+dpbgidln_hv18_snw                          minr=1e-3

     7: type=n
+ lmin=1e-006-dxln_hv18_snw lmax=1e-005-dxln_hv18_snw wmin=1e-005-dxwn_hv18_snw
+ wmax=2e-005-dxwn_hv18_snw version=4.5               binunit=2
+ paramchk=1                mobmod=0                  capmod=2
+ igcmod=0                  igbmod=0                  diomod=1
+ rdsmod=1                  rbodymod=0                rgeomod=1
+ rgatemod=1*rgflag_hv18_snw_spw                      permod=1
+ acnqsmod=0                trnqsmod=0                tempmod=0
+ tnom=25                   toxe=toxn_hv18_snw        toxm=3.58e-009
+ dtox=2.7936e-010          epsrox=3.9                wint=0
+ lint=2.45e-007            ll=0                      wl=0
+ lln=1                     wln=1                     lw=0
+ ww=0                      lwn=1                     wwn=1
+ lwl=0                     wwl=0                     llc=0
+ wlc=0                     lwc=0                     wwc=0
+ lwlc=0                    wwlc=0                    xl=1e-08+dxln_hv18_snw
+ xw=0+dxwn_hv18_snw        dlc=ddlcn_hv18_snw        dwc=0
+ xpart=1                   toxref=3e-009             dlcig=2.5e-009
+ vth0=0.56944187+dvthn_hv18_snw                      lvth0=8.0746777e-009+dlvthn_hv18_snw
+ wvth0=-1.5943339e-007+dwvthn_hv18_snw               pvth0=1.3740088e-013+dpvthn_hv18_snw
+ k1=0.24874                k2=0.056483933+dk2n_hv18_snw
+ lk2=9.5305958e-009+dlk2n_hv18_snw                   wk2=7.3413614e-008+dwk2n_hv18_snw
+ pk2=-3.5928691e-014+dpk2n_hv18_snw                  k3=-1.82
+ k3b=1.0692                w0=0                      dvt0=1.1319
+ dvt1=0.0055               dvt2=0.00050391           dvt0w=0
+ dvt1w=0                   dvt2w=0                   dsub=0.25
+ minv=-0.44435378          lminv=-4.4004189e-010     wminv=-9.2444111e-010
+ pminv=8.8007718e-015      voffl=-5e-009             dvtp0=2.1516e-007
+ dvtp1=0.01                lpe0=5e-007               lpeb=2.4075e-007
+ xj=6.7e-008               ngate=8.5997e+020         ndep=9e+017
+ nsd=1e+020                phin=0.185                cdsc=0
+ cdscb=0                   cdscd=0                   cit=8.4960902e-005+dcitn_hv18_snw
+ lcit=4.6799433e-010+dlcitn_hv18_snw                 wcit=2.4144467e-009+dwcitn_hv18_snw
+ pcit=-2.1538643e-015+dpcitn_hv18_snw                voff=-0.19070452+dvoffn_hv18_snw
+ lvoff=3.383867e-008+dlvoffn_hv18_snw                wvoff=2.7574154e-007+dwvoffn_hv18_snw
+ pvoff=-2.412488e-013+dpvoffn_hv18_snw               nfactor=0.6+dnfactorn_hv18_snw
+ eta0=0.0010241+deta0n_hv18_snw                      etab=-0.08661572
+ letab=2.0901572e-014      wetab=6.7173438e-007      petab=-2.0901572e-019
+ ud=0                      lud=0                     wud=0
+ pud=0                     u0=0.036258391+du0n_hv18_snw
+ lu0=3.8233568e-009+dlu0n_hv18_snw                   wu0=-5.1678385e-008+dwu0n_hv18_snw
+ pu0=2.6831161e-014+dpu0n_hv18_snw                   ua=-8.3156606e-010
+ lua=1.4209792e-016        wua=1.1263422e-015        pua=-1.4217497e-021
+ ub=2.424545e-018          lub=1.5734968e-026        wub=-5.2345785e-024
+ pub=7.4123574e-030        uc=1.1528399e-010         luc=4.327785e-017
+ wuc=-2.0775274e-016       puc=7.4783612e-022        vsat=160288.87+dvsatn_hv18_snw
+ lvsat=-0.0027501105+dlvsatn_hv18_snw                wvsat=-0.023110739+dwvsatn_hv18_snw
+ pvsat=2.2001654e-007+dpvsatn_hv18_snw               a0=2.6164097+da0n_hv18_snw-0.026*ff_flag_hv18_snw_spw+0.026*ss_flag_hv18_snw_spw
+ la0=-1.6109046e-006+dla0n_hv18_snw+2.4752e-07*ff_flag_hv18_snw_spw-2.4752e-07*ss_flag_hv18_snw_spw
+ wa0=-5.0327115e-006+dwa0n_hv18_snw-5.77776e-08*ff_flag_hv18_snw_spw+5.77776e-08*ss_flag_hv18_snw_spw
+ pa0=-9.8303381e-013+dpa0n_hv18_snw+5.50049e-13*ff_flag_hv18_snw_spw-5.50049e-13*ss_flag_hv18_snw_spw
+ ags=0.67467088+dagsn_hv18_snw+0.0115556*ff_flag_hv18_snw_spw-0.0173334*ss_flag_hv18_snw_spw
+ lags=-2.4162891e-007+dlagsn_hv18_snw-1.10009e-07*ff_flag_hv18_snw_spw+1.65014e-07*ss_flag_hv18_snw_spw
+ wags=-1.0606887e-007+dwagsn_hv18_snw+1.15555e-07*ff_flag_hv18_snw_spw+3.3e-13*ss_flag_hv18_snw_spw
+ pags=-4.8843563e-014+dpagsn_hv18_snw-1.10009e-12*ff_flag_hv18_snw_spw-3.3e-18*ss_flag_hv18_snw_spw
+ a1=0                      a2=1                      b0=0
+ b1=0                      keta=-0.036820747         lketa=-2.2574961e-008
+ wketa=-1.3219118e-007     pketa=-6.9767092e-014     dwg=0
+ dwb=0                     pclm=0.014764894          lpclm=2.2001544e-009
+ wpclm=4.6221478e-009      ppclm=-4.4003309e-014     pdiblc1=0
+ pdiblc2=0.0001            pdiblcb=0                 drout=0.56
+ pvag=0.45                 delta=0.01                pscbe1=9.264e+008
+ pscbe2=1e-020             fprout=100                pdits=0
+ pditsd=0                  pditsl=0                  rsh=17.5
+ rsw=65.35                 rdw=600                   prwg=0
+ prwb=0                    wr=1                      alpha0=6.3669e-08
+ alpha1=1.5                beta0=29.5                agidl=4e-009+dagidln_hv18_snw
+ bgidl=8e+009+dbgidln_hv18_snw                       cgidl=21.599
+ egidl=0.55661             aigbacc=0.01238           bigbacc=0.006109
+ cigbacc=0.2809            nigbacc=4.05              aigbinv=0.02
+ bigbinv=0.02              cigbinv=0.006             eigbinv=1.1
+ nigbinv=1                 aigc=0.009898             bigc=0.001383
+ cigc=1.515e-005           aigsd=0.0086              bigsd=0.0004353
+ cigsd=3.925e-020          nigc=1                    poxedge=1
+ pigcd=1.672               ntox=1                    xrcrg1=12
+ xrcrg2=1                  cgso=cgson_hv18_snw       cgdo=cgdon_hv18_snw
+ cgbo=0                    cgdl=cgdln_hv18_snw       cgsl=cgsln_hv18_snw
+ clc=1e-007                cle=0.6                   cf=cfn_hv18_snw
+ ckappas=0.6               ckappad=0.6               acde=0.3
+ moin=5.2                  noff=2.9337               voffcv=-0.16925
+ tvoff=0.001               ltvoff=0                  wtvoff=0
+ ptvoff=0                  kt1=-0.17823771+dkt1n_hv18_snw
+ lkt1=-4.4195955e-008+dlkt1n_hv18_snw                wkt1=-1.9917657e-007+dwkt1n_hv18_snw
+ pkt1=1.7876344e-013+dpkt1n_hv18_snw                 kt1l=0
+ kt2=-0.040692121          lkt2=-6.9393709e-009      wkt2=-7.4354595e-008
+ pkt2=-2.7656069e-014      ute=-1.35                 ua1=2.0513966e-009
+ lua1=-7.6384359e-017      wua1=-1.5005088e-014      pua1=1.1534147e-020
+ ub1=-2.8031643e-018       lub1=7.2880958e-025       wub1=2.3003992e-023
+ pub1=-1.9399076e-029      uc1=8.0649612e-011        luc1=4.1990152e-017
+ wuc1=6.3635543e-016       puc1=-4.2991233e-022      prt=0
+ at=11555.427+datn_hv18_snw                          lat=-0.11000882+dlatn_hv18_snw
+ jss=5.23e-007             jsws=2.52e-013            jswgs=2.52e-013
+ njs=1.02                  njd=1.02                  ijthsfwd=0.01
+ ijthdfwd=0.01             ijthsrev=0.01             ijthdrev=0.01
+ bvs=8.4                   xjbvs=1                   xjbvd=1
+ jsd=1.03e-006             jswd=1.14e-012            jswgd=1.14e-012
+ bvd=14.1                  jtsswgs=3e-009+djtsswgsn_hv18_snw
+ jtsswgd=6e-008+djtsswgdn_hv18_snw                   njtsswg=20+dnjtsswgn_hv18_snw
+ xtsswgs=0.1               xtsswgd=0.75              tnjtsswg=0.5
+ vtsswgs=0.7               vtsswgd=0.05              pbs=0.5
+ cjs=cjsn_hv18_snw         mjs=0.24                  pbsws=0.3
+ cjsws=cjswsn_hv18_snw     mjsws=0.013               pbswgs=0.5
+ cjswgs=cjswgsn_hv18_snw   mjswgs=0.3                pbd=0.56
+ cjd=cjdn_hv18_snw         mjd=0.36                  pbswd=0.8
+ cjswd=cjswdn_hv18_snw     mjswd=0.31                pbswgd=0.8
+ cjswgd=cjswgdn_hv18_snw   mjswgd=0.36               tpb=0.002
+ tcj=0.0018                tpbsw=0.0025              tcjsw=0.0011
+ tpbswg=0.0028             tcjswg=0.00157            xtis=3
+ xtid=3                    dmcg=6.4e-08              dmci=6.4e-08
+ dmdg=0                    dmcgt=0                   dwj=0
+ xgw=0                     xgl=-1.09e-08             rshg=15.6
+ gbmin=1e-012              rbpb=50                   rbpd=50
+ rbps=50                   rbdb=50                   rbsb=50
+ ngcon=1                   wnfactor=0+dwnfactorn_hv18_snw
+ lnfactor=0+dlnfactorn_hv18_snw                      pnfactor=0+dpnfactorn_hv18_snw
+ weta0=0+dweta0n_hv18_snw  wat=0+dwatn_hv18_snw      pat=0+dpatn_hv18_snw
+ lagidl=0+dlagidln_hv18_snw                          wagidl=0+dwagidln_hv18_snw
+ pagidl=0+dpagidln_hv18_snw                          lbgidl=0+dlbgidln_hv18_snw
+ wbgidl=0+dwbgidln_hv18_snw                          pbgidl=0+dpbgidln_hv18_snw
+ minr=1e-3

     8: type=n
+ lmin=9e-007-dxln_hv18_snw lmax=1e-006-dxln_hv18_snw wmin=1e-005-dxwn_hv18_snw
+ wmax=2e-005-dxwn_hv18_snw version=4.5               binunit=2
+ paramchk=1                mobmod=0                  capmod=2
+ igcmod=0                  igbmod=0                  diomod=1
+ rdsmod=1                  rbodymod=0                rgeomod=1
+ rgatemod=1*rgflag_hv18_snw_spw                      permod=1
+ acnqsmod=0                trnqsmod=0                tempmod=0
+ tnom=25                   toxe=toxn_hv18_snw        toxm=3.58e-009
+ dtox=2.7936e-010          epsrox=3.9                wint=0
+ lint=2.45e-007            ll=0                      wl=0
+ lln=1                     wln=1                     lw=0
+ ww=0                      lwn=1                     wwn=1
+ lwl=0                     wwl=0                     llc=0
+ wlc=0                     lwc=0                     wwc=0
+ lwlc=0                    wwlc=0                    xl=1e-08+dxln_hv18_snw
+ xw=0+dxwn_hv18_snw        dlc=ddlcn_hv18_snw        dwc=0
+ xpart=1                   toxref=3e-009             dlcig=2.5e-009
+ vth0=0.48412845+dvthn_hv18_snw                      lvth0=5.2437653e-008+dlvthn_hv18_snw
+ wvth0=4.8783548e-007+dwvthn_hv18_snw                pvth0=-1.9917893e-013+dpvthn_hv18_snw
+ k1=0.24874                k2=0.081116248+dk2n_hv18_snw
+ lk2=-3.2782081e-009+dlk2n_hv18_snw                  wk2=1.0528756e-007+dwk2n_hv18_snw
+ pk2=-5.2503141e-014+dpk2n_hv18_snw                  k3=-1.82
+ k3b=1.0692                w0=0                      dvt0=1.1319
+ dvt1=0.0055               dvt2=0.00050391           dvt0w=0
+ dvt1w=0                   dvt2w=0                   dsub=0.25
+ minv=-0.4452001           lminv=4.3679782e-014      wminv=1.600096e-008
+ pminv=-4.3679782e-019     voffl=-5e-009             dvtp0=2.1516e-007
+ dvtp1=0.01                lpe0=5e-007               lpeb=2.4075e-007
+ xj=6.7e-008               ngate=8.5997e+020         ndep=9e+017
+ nsd=1e+020                phin=0.185                cdsc=0
+ cdscb=0                   cdscd=0                   cit=0.00072379703+dcitn_hv18_snw
+ lcit=1.3579954e-010+dlcitn_hv18_snw                 wcit=-4.3165132e-009+dwcitn_hv18_snw
+ pcit=1.3462349e-015+dpcitn_hv18_snw                 voff=-0.098120713+dvoffn_hv18_snw
+ lvoff=-1.4304909e-008+dlvoffn_hv18_snw              wvoff=-8.0223287e-007+dwvoffn_hv18_snw
+ pvoff=3.1929789e-013+dpvoffn_hv18_snw               nfactor=0.6+dnfactorn_hv18_snw
+ eta0=0.0010241+deta0n_hv18_snw                      etab=-0.08661568
+ wetab=6.7173398e-007      ud=0                      lud=0
+ wud=0                     pud=0                     u0=0.048067175+du0n_hv18_snw
+ lu0=-2.3172112e-009+dlu0n_hv18_snw                  wu0=-4.9303754e-008+dwu0n_hv18_snw
+ pu0=2.5596352e-014+dpu0n_hv18_snw                   ua=5.5526707e-011
+ lua=-3.1919032e-016       wua=-5.286125e-015        pua=1.9127333e-021
+ ub=1.9701221e-018         lub=2.5203483e-025        wub=4.2739786e-024
+ pub=2.4679077e-030        uc=2.9905821e-010         luc=-5.2284745e-017
+ wuc=3.1899736e-016        puc=4.7392607e-022        vsat=197000.37+dvsatn_hv18_snw
+ lvsat=-0.021840087+dlvsatn_hv18_snw                 wvsat=0.81999674+dwvsatn_hv18_snw
+ pvsat=-2.1839935e-007+dpvsatn_hv18_snw              a0=1.8546374+da0n_hv18_snw+0.87*ff_flag_hv18_snw_spw-0.45*ss_flag_hv18_snw_spw
+ la0=-1.214783e-006+dla0n_hv18_snw-2.184e-07*ff_flag_hv18_snw_spw+0.0*ss_flag_hv18_snw_spw
+ wa0=-9.8765688e-006+dwa0n_hv18_snw+9.4e-06*ff_flag_hv18_snw_spw-1.78e-05*ss_flag_hv18_snw_spw
+ pa0=1.535772e-012+dpa0n_hv18_snw-4.368e-12*ff_flag_hv18_snw_spw+8.736e-12*ss_flag_hv18_snw_spw
+ ags=-0.30084652+dagsn_hv18_snw-1.46*ff_flag_hv18_snw_spw+1.14*ss_flag_hv18_snw_spw
+ lags=2.6564014e-007+dlagsn_hv18_snw+6.552e-07*ff_flag_hv18_snw_spw-4.368e-07*ss_flag_hv18_snw_spw
+ wags=1.8932875e-006+dwagsn_hv18_snw-2e-06*ff_flag_hv18_snw_spw+0.0*ss_flag_hv18_snw_spw
+ pags=-1.0885089e-012+dpagsn_hv18_snw+0.0*ff_flag_hv18_snw_spw+0.0*ss_flag_hv18_snw_spw
+ a1=0                      a2=1                      b0=0
+ b1=0                      keta=-0.16141923          lketa=4.2216249e-008
+ wketa=1.6290923e-006      pketa=-9.8563449e-013     dwg=0
+ dwb=0                     pclm=0.01899596           wpclm=-7.99996e-008
+ pdiblc1=0                 pdiblc2=9.9999962e-005    lpdiblc2=1.9655804e-017
+ wpdiblc2=7.559962e-016    ppdiblc2=-3.9311803e-022  pdiblcb=0
+ drout=0.56                pvag=0.45                 delta=0.01
+ pscbe1=9.264e+008         pscbe2=1e-020             fprout=100
+ pdits=0                   pditsd=0                  pditsl=0
+ rsh=17.5                  rsw=65.35                 rdw=600
+ prwg=0                    prwb=0                    wr=1
+ alpha0=6.3669e-08         alpha1=1.5                beta0=29.5
+ agidl=4e-009+dagidln_hv18_snw                       bgidl=8e+009+dbgidln_hv18_snw
+ cgidl=21.599              egidl=0.55661             aigbacc=0.01238
+ bigbacc=0.006109          cigbacc=0.2809            nigbacc=4.05
+ aigbinv=0.02              bigbinv=0.02              cigbinv=0.006
+ eigbinv=1.1               nigbinv=1                 aigc=0.009898
+ bigc=0.001383             cigc=1.515e-005           aigsd=0.0086
+ bigsd=0.0004353           cigsd=3.925e-020          nigc=1
+ poxedge=1                 pigcd=1.672               ntox=1
+ xrcrg1=12                 xrcrg2=1                  cgso=cgson_hv18_snw
+ cgdo=cgdon_hv18_snw       cgbo=0                    cgdl=cgdln_hv18_snw
+ cgsl=cgsln_hv18_snw       clc=1e-007                cle=0.6
+ cf=cfn_hv18_snw           ckappas=0.6               ckappad=0.6
+ acde=0.3                  moin=5.2                  noff=2.9337
+ voffcv=-0.16925           tvoff=0.001               ltvoff=0
+ wtvoff=0                  ptvoff=0                  kt1=-0.29405761+dkt1n_hv18_snw
+ lkt1=1.6030397e-008+dlkt1n_hv18_snw                 wkt1=7.7123614e-007+dwkt1n_hv18_snw
+ pkt1=-3.2585117e-013+dpkt1n_hv18_snw                kt1l=0
+ kt2=-0.045452741          lkt2=-4.4638483e-009      wkt2=-1.0718625e-006
+ pkt2=4.9104806e-013       ute=-1.35                 ua1=1.2228511e-009
+ lua1=3.5445931e-016       wua1=2.2119489e-014       pua1=-7.7706331e-021
+ ub1=-2.3990897e-019       lub1=-6.0408321e-025      wub1=-5.3974901e-023
+ pub1=2.0629948e-029       uc1=-1.9212379e-010       luc1=1.8383232e-016
+ wuc1=5.461344e-015        puc1=-2.9389064e-021      prt=0
+ at=-200000+datn_hv18_snw  jss=5.23e-007             jsws=2.52e-013
+ jswgs=2.52e-013           njs=1.02                  njd=1.02
+ ijthsfwd=0.01             ijthdfwd=0.01             ijthsrev=0.01
+ ijthdrev=0.01             bvs=8.4                   xjbvs=1
+ xjbvd=1                   jsd=1.03e-006             jswd=1.14e-012
+ jswgd=1.14e-012           bvd=14.1                  jtsswgs=3e-009+djtsswgsn_hv18_snw
+ jtsswgd=6e-008+djtsswgdn_hv18_snw                   njtsswg=20+dnjtsswgn_hv18_snw
+ xtsswgs=0.1               xtsswgd=0.75              tnjtsswg=0.5
+ vtsswgs=0.7               vtsswgd=0.05              pbs=0.5
+ cjs=cjsn_hv18_snw         mjs=0.24                  pbsws=0.3
+ cjsws=cjswsn_hv18_snw     mjsws=0.013               pbswgs=0.5
+ cjswgs=cjswgsn_hv18_snw   mjswgs=0.3                pbd=0.56
+ cjd=cjdn_hv18_snw         mjd=0.36                  pbswd=0.8
+ cjswd=cjswdn_hv18_snw     mjswd=0.31                pbswgd=0.8
+ cjswgd=cjswgdn_hv18_snw   mjswgd=0.36               tpb=0.002
+ tcj=0.0018                tpbsw=0.0025              tcjsw=0.0011
+ tpbswg=0.0028             tcjswg=0.00157            xtis=3
+ xtid=3                    dmcg=6.4e-08              dmci=6.4e-08
+ dmdg=0                    dmcgt=0                   dwj=0
+ xgw=0                     xgl=-1.09e-08             rshg=15.6
+ gbmin=1e-012              rbpb=50                   rbpd=50
+ rbps=50                   rbdb=50                   rbsb=50
+ ngcon=1                   wnfactor=0+dwnfactorn_hv18_snw
+ lnfactor=0+dlnfactorn_hv18_snw                      pnfactor=0+dpnfactorn_hv18_snw
+ weta0=0+dweta0n_hv18_snw  lat=0+dlatn_hv18_snw      wat=0+dwatn_hv18_snw
+ pat=0+dpatn_hv18_snw      lagidl=0+dlagidln_hv18_snw
+ wagidl=0+dwagidln_hv18_snw                          pagidl=0+dpagidln_hv18_snw
+ lbgidl=0+dlbgidln_hv18_snw                          wbgidl=0+dwbgidln_hv18_snw
+ pbgidl=0+dpbgidln_hv18_snw                          minr=1e-3

     9: type=n
+ lmin=8.5e-007-dxln_hv18_snw                         lmax=9e-007-dxln_hv18_snw
+ wmin=1e-005-dxwn_hv18_snw wmax=2e-005-dxwn_hv18_snw version=4.5
+ binunit=2                 paramchk=1                mobmod=0
+ capmod=2                  igcmod=0                  igbmod=0
+ diomod=1                  rdsmod=1                  rbodymod=0
+ rgeomod=1                 rgatemod=1*rgflag_hv18_snw_spw
+ permod=1                  acnqsmod=0                trnqsmod=0
+ tempmod=0                 tnom=25                   toxe=toxn_hv18_snw
+ toxm=3.58e-009            dtox=2.7936e-010          epsrox=3.9
+ wint=0                    lint=2.45e-007            ll=0
+ wl=0                      lln=1                     wln=1
+ lw=0                      ww=0                      lwn=1
+ wwn=1                     lwl=0                     wwl=0
+ llc=0                     wlc=0                     lwc=0
+ wwc=0                     lwlc=0                    wwlc=0
+ xl=1e-08+dxln_hv18_snw    xw=0+dxwn_hv18_snw        dlc=ddlcn_hv18_snw
+ dwc=0                     xpart=1                   toxref=3e-009
+ dlcig=2.5e-009            vth0=0.48873093+dvthn_hv18_snw
+ lvth0=5.0504611e-008+dlvthn_hv18_snw                wvth0=1.8665507e-006+dwvthn_hv18_snw
+ pvth0=-7.7823931e-013+dpvthn_hv18_snw               k1=0.24874
+ k2=0.092972891+dk2n_hv18_snw                        lk2=-8.2579979e-009+dlk2n_hv18_snw
+ wk2=1.5003493e-007+dwk2n_hv18_snw                   pk2=-7.1297039e-014+dpk2n_hv18_snw
+ k3=-1.82                  k3b=1.0692                w0=0
+ dvt0=1.1319               dvt1=0.0055               dvt2=0.00050391
+ dvt0w=0                   dvt1w=0                   dvt2w=0
+ dsub=0.25                 minv=-0.44519999          wminv=1.599992e-008
+ voffl=-5e-009             dvtp0=2.1516e-007         dvtp1=0.01
+ lpe0=5e-007               lpeb=2.4075e-007          xj=6.7e-008
+ ngate=8.5997e+020         ndep=9e+017               nsd=1e+020
+ phin=0.185                cdsc=0                    cdscb=0
+ cdscd=0                   cit=0.0022499185+dcitn_hv18_snw
+ lcit=-5.0517147e-010+dlcitn_hv18_snw                wcit=-1.233396e-008+dwcitn_hv18_snw
+ pcit=4.7135624e-015+dpcitn_hv18_snw                 voff=-0.041012991+dvoffn_hv18_snw
+ lvoff=-3.8290152e-008+dlvoffn_hv18_snw              wvoff=-1.9822701e-006+dwvoffn_hv18_snw
+ pvoff=8.1491353e-013+dpvoffn_hv18_snw               nfactor=0.6+dnfactorn_hv18_snw
+ eta0=0.0010241+deta0n_hv18_snw                      etab=-0.08661568
+ wetab=6.7173398e-007      ud=0                      lud=0
+ wud=0                     pud=0                     u0=0.055906941+du0n_hv18_snw
+ lu0=-5.6099128e-009+dlu0n_hv18_snw                  wu0=-1.1800741e-007+dwu0n_hv18_snw
+ pu0=5.4451888e-014+dpu0n_hv18_snw                   ua=1.1672937e-009
+ lua=-7.8613245e-016       wua=-2.6227841e-014       pua=1.0708254e-020
+ ub=2.2475641e-018         lub=1.3550923e-025        wub=1.1082359e-023
+ pub=-3.9161226e-031       uc=4.0241692e-010         luc=-9.5695402e-017
+ wuc=1.3955901e-015        puc=2.1757134e-023        vsat=85800.826+dvsatn_hv18_snw
+ lvsat=0.02486372+dlvsatn_hv18_snw                   wvsat=1.4839909+dwvsatn_hv18_snw
+ pvsat=-4.9727689e-007+dpvsatn_hv18_snw              a0=4.1962996+da0n_hv18_snw-2.61*ff_flag_hv18_snw_spw+0.29*ss_flag_hv18_snw_spw
+ la0=-2.1982811e-006+dla0n_hv18_snw+1.2432e-06*ff_flag_hv18_snw_spw-3.108e-07*ss_flag_hv18_snw_spw
+ wa0=-4.2346603e-005+dwa0n_hv18_snw+4.34e-05*ff_flag_hv18_snw_spw-1.18e-05*ss_flag_hv18_snw_spw
+ pa0=1.5173186e-011+dpa0n_hv18_snw-1.8648e-11*ff_flag_hv18_snw_spw+6.216e-12*ss_flag_hv18_snw_spw
+ ags=-3.4024642+dagsn_hv18_snw+0.84*ff_flag_hv18_snw_spw-0.64*ss_flag_hv18_snw_spw
+ lags=1.5683196e-006+dlagsn_hv18_snw-3.108e-07*ff_flag_hv18_snw_spw+3.108e-07*ss_flag_hv18_snw_spw
+ wags=3.4054759e-005+dwagsn_hv18_snw-1.68e-05*ff_flag_hv18_snw_spw+1.48e-05*ss_flag_hv18_snw_spw
+ pags=-1.4596327e-011+dpagsn_hv18_snw+6.216e-12*ff_flag_hv18_snw_spw-6.216e-12*ss_flag_hv18_snw_spw
+ a1=0                      a2=1                      b0=0
+ b1=0                      keta=-0.23888887          lketa=7.4753499e-008
+ wketa=-1.898913e-007      pketa=-2.2166139e-013     dwg=0
+ dwb=0                     pclm=0.048536464          lpclm=-1.2407012e-008
+ wpclm=-6.7140464e-007     ppclm=2.4839012e-013      pdiblc1=0
+ pdiblc2=0.00010000065     lpdiblc2=-2.7039404e-016  wpdiblc2=-9.5039525e-015
+ ppdiblc2=3.9160604e-021   pdiblcb=0                 drout=0.56
+ pvag=0.45                 delta=0.01                pscbe1=9.264e+008
+ pscbe2=1e-020             fprout=100                pdits=0
+ pditsd=0                  pditsl=0                  rsh=17.5
+ rsw=65.35                 rdw=600                   prwg=0
+ prwb=0                    wr=1                      alpha0=6.3669e-08
+ alpha1=1.5                beta0=29.5                agidl=4e-009+dagidln_hv18_snw
+ bgidl=8e+009+dbgidln_hv18_snw                       cgidl=21.599
+ egidl=0.55661             aigbacc=0.01238           bigbacc=0.006109
+ cigbacc=0.2809            nigbacc=4.05              aigbinv=0.02
+ bigbinv=0.02              cigbinv=0.006             eigbinv=1.1
+ nigbinv=1                 aigc=0.009898             bigc=0.001383
+ cigc=1.515e-005           aigsd=0.0086              bigsd=0.0004353
+ cigsd=3.925e-020          nigc=1                    poxedge=1
+ pigcd=1.672               ntox=1                    xrcrg1=12
+ xrcrg2=1                  cgso=cgson_hv18_snw       cgdo=cgdon_hv18_snw
+ cgbo=0                    cgdl=cgdln_hv18_snw       cgsl=cgsln_hv18_snw
+ clc=1e-007                cle=0.6                   cf=cfn_hv18_snw
+ ckappas=0.6               ckappad=0.6               acde=0.3
+ moin=5.2                  noff=2.9337               voffcv=-0.16925
+ tvoff=0.001               ltvoff=0                  wtvoff=0
+ ptvoff=0                  kt1=-0.1065595+dkt1n_hv18_snw
+ lkt1=-6.2718809e-008+dlkt1n_hv18_snw                wkt1=-3.008985e-006+dwkt1n_hv18_snw
+ pkt1=1.2618417e-012+dpkt1n_hv18_snw                 kt1l=0
+ kt2=-0.022662783          lkt2=-1.4035631e-008      wkt2=-3.8162624e-007
+ pkt2=2.0114882e-013       ute=-1.35                 ua1=9.0427686e-010
+ lua1=4.8826048e-016       wua1=3.9641031e-014       pua1=-1.5129681e-020
+ ub1=-3.6295869e-018       lub1=8.1958152e-025       wub1=-1.5467539e-023
+ pub1=4.4568559e-030       uc1=6.7767539e-010        luc1=-1.8148333e-016
+ wuc1=-1.0875245e-014      puc1=3.9224611e-021       prt=0
+ at=-200000+datn_hv18_snw  jss=5.23e-007             jsws=2.52e-013
+ jswgs=2.52e-013           njs=1.02                  njd=1.02
+ ijthsfwd=0.01             ijthdfwd=0.01             ijthsrev=0.01
+ ijthdrev=0.01             bvs=8.4                   xjbvs=1
+ xjbvd=1                   jsd=1.03e-006             jswd=1.14e-012
+ jswgd=1.14e-012           bvd=14.1                  jtsswgs=3e-009+djtsswgsn_hv18_snw
+ jtsswgd=6e-008+djtsswgdn_hv18_snw                   njtsswg=20+dnjtsswgn_hv18_snw
+ xtsswgs=0.1               xtsswgd=0.75              tnjtsswg=0.5
+ vtsswgs=0.7               vtsswgd=0.05              pbs=0.5
+ cjs=cjsn_hv18_snw         mjs=0.24                  pbsws=0.3
+ cjsws=cjswsn_hv18_snw     mjsws=0.013               pbswgs=0.5
+ cjswgs=cjswgsn_hv18_snw   mjswgs=0.3                pbd=0.56
+ cjd=cjdn_hv18_snw         mjd=0.36                  pbswd=0.8
+ cjswd=cjswdn_hv18_snw     mjswd=0.31                pbswgd=0.8
+ cjswgd=cjswgdn_hv18_snw   mjswgd=0.36               tpb=0.002
+ tcj=0.0018                tpbsw=0.0025              tcjsw=0.0011
+ tpbswg=0.0028             tcjswg=0.00157            xtis=3
+ xtid=3                    dmcg=6.4e-08              dmci=6.4e-08
+ dmdg=0                    dmcgt=0                   dwj=0
+ xgw=0                     xgl=-1.09e-08             rshg=15.6
+ gbmin=1e-012              rbpb=50                   rbpd=50
+ rbps=50                   rbdb=50                   rbsb=50
+ ngcon=1                   wnfactor=0+dwnfactorn_hv18_snw
+ lnfactor=0+dlnfactorn_hv18_snw                      pnfactor=0+dpnfactorn_hv18_snw
+ weta0=0+dweta0n_hv18_snw  lat=0+dlatn_hv18_snw      wat=0+dwatn_hv18_snw
+ pat=0+dpatn_hv18_snw      lagidl=0+dlagidln_hv18_snw
+ wagidl=0+dwagidln_hv18_snw                          pagidl=0+dpagidln_hv18_snw
+ lbgidl=0+dlbgidln_hv18_snw                          wbgidl=0+dwbgidln_hv18_snw
+ pbgidl=0+dpbgidln_hv18_snw                          minr=1e-3

     10: type=n
+ lmin=0.792e-06            lmax=8.5e-007-dxln_hv18_snw
+ wmin=1e-005-dxwn_hv18_snw wmax=2e-005-dxwn_hv18_snw version=4.5
+ binunit=2                 paramchk=1                mobmod=0
+ capmod=2                  igcmod=0                  igbmod=0
+ diomod=1                  rdsmod=1                  rbodymod=0
+ rgeomod=1                 rgatemod=1*rgflag_hv18_snw_spw
+ permod=1                  acnqsmod=0                trnqsmod=0
+ tempmod=0                 tnom=25                   toxe=toxn_hv18_snw
+ toxm=3.58e-009            dtox=2.7936e-010          epsrox=3.9
+ wint=0                    lint=2.45e-007            ll=0
+ wl=0                      lln=1                     wln=1
+ lw=0                      ww=0                      lwn=1
+ wwn=1                     lwl=0                     wwl=0
+ llc=0                     wlc=0                     lwc=0
+ wwc=0                     lwlc=0                    wwlc=0
+ xl=1e-08+dxln_hv18_snw    xw=0+dxwn_hv18_snw        dlc=ddlcn_hv18_snw
+ dwc=0                     xpart=1                   toxref=3e-009
+ dlcig=2.5e-009            vth0=0.80353291+dvthn_hv18_snw
+ lvth0=-6.5972119e-008+dlvthn_hv18_snw               wvth0=-2.1862291e-006+dwvthn_hv18_snw
+ pvth0=7.2128919e-013+dpvthn_hv18_snw                k1=0.24874
+ k2=0.15167775+dk2n_hv18_snw                         lk2=-2.9978796e-008+dlk2n_hv18_snw
+ wk2=-4.8528143e-007+dwk2n_hv18_snw                  pk2=1.6377001e-013+dpk2n_hv18_snw
+ k3=-1.82                  k3b=1.0692                w0=0
+ dvt0=1.1319               dvt1=0.0055               dvt2=0.00050391
+ dvt0w=0                   dvt1w=0                   dvt2w=0
+ dsub=0.25                 minv=-0.44007999          lminv=-1.8944e-009
+ wminv=1.599992e-008       pminv=-3.1127145e-026     voffl=-5e-009
+ dvtp0=2.1516e-007         dvtp1=0.01                lpe0=5e-007
+ lpeb=2.4075e-007          xj=6.7e-008               ngate=8.5997e+020
+ ndep=9e+017               nsd=1e+020                phin=0.185
+ cdsc=0                    cdscb=0                   cdscd=0
+ cit=0.001604392+dcitn_hv18_snw                      lcit=-2.6632667e-010+dlcitn_hv18_snw
+ wcit=-1.1853099e-008+dwcitn_hv18_snw                pcit=4.535644e-015+dpcitn_hv18_snw
+ voff=-0.26865922+dvoffn_hv18_snw                    lvoff=4.5938953e-008+dlvoffn_hv18_snw
+ wvoff=1.5565122e-006+dwvoffn_hv18_snw               pvoff=-4.9443593e-013+dpvoffn_hv18_snw
+ nfactor=0.6+dnfactorn_hv18_snw                      eta0=0.0010241+deta0n_hv18_snw
+ etab=-0.08661568          wetab=6.7173398e-007      ud=0
+ lud=0                     wud=0                     pud=0
+ u0=0.019657112+du0n_hv18_snw                        lu0=7.8025238e-009+dlu0n_hv18_snw
+ wu0=2.2474288e-007+dwu0n_hv18_snw                   pu0=-7.2365718e-014+dpu0n_hv18_snw
+ ua=-3.2519672e-009        lua=8.4899408e-016        wua=2.9515172e-014
+ pua=-9.9166608e-021       ub=3.0432308e-018         lub=-1.5888746e-025
+ wub=-1.8839908e-023       pub=1.0679627e-029        uc=4.6832487e-010
+ luc=-1.2008134e-016       wuc=1.9267121e-015        puc=-1.74758e-022
+ vsat=108200.52+dvsatn_hv18_snw                      lvsat=0.016575834+dlvsatn_hv18_snw
+ wvsat=1.0359948+dwvsatn_hv18_snw                    pvsat=-3.3151834e-007+dpvsatn_hv18_snw
+ a0=0.93596488+da0n_hv18_snw+2.99*ff_flag_hv18_snw_spw-3.11*ss_flag_hv18_snw_spw
+ la0=-9.9195729e-007+dla0n_hv18_snw-8.288e-07*ff_flag_hv18_snw_spw+9.472e-07*ss_flag_hv18_snw_spw
+ wa0=1.1231559e-005+dwa0n_hv18_snw-6e-07*ff_flag_hv18_snw_spw+1.78e-05*ss_flag_hv18_snw_spw
+ pa0=-4.6507335e-012+dpa0n_hv18_snw-2.368e-12*ff_flag_hv18_snw_spw-4.736e-12*ss_flag_hv18_snw_spw
+ ags=-1.5562664+dagsn_hv18_snw+0.0*ff_flag_hv18_snw_spw+1.48*ss_flag_hv18_snw_spw
+ lags=8.8522638e-007+dlagsn_hv18_snw+0.0*ff_flag_hv18_snw_spw-4.736e-07*ss_flag_hv18_snw_spw
+ wags=1.1118424e-005+dwagsn_hv18_snw+0.0*ff_flag_hv18_snw_spw-1.48e-05*ss_flag_hv18_snw_spw
+ pags=-6.109883e-012+dpagsn_hv18_snw+0.0*ff_flag_hv18_snw_spw+4.736e-12*ss_flag_hv18_snw_spw
+ a1=0                      a2=1                      b0=0
+ b1=0                      keta=-0.18053184          lketa=5.3161396e-008
+ wketa=3.1309835e-007      pketa=-4.0776756e-013     dwg=0
+ dwb=0                     pclm=-0.11294416          lpclm=4.7340819e-008
+ wpclm=1.2794016e-006      ppclm=-4.7340819e-013     pdiblc1=0
+ pdiblc2=-0.0011800002     lpdiblc2=4.7360004e-010   wpdiblc2=4.1519793e-015
+ ppdiblc2=-1.1366343e-021  pdiblcb=0                 drout=0.56
+ pvag=0.45                 delta=0.01                pscbe1=9.264e+008
+ pscbe2=1e-020             fprout=100                pdits=0
+ pditsd=0                  pditsl=0                  rsh=17.5
+ rsw=65.35                 rdw=600                   prwg=0
+ prwb=0                    wr=1                      alpha0=6.3669e-08
+ alpha1=1.5                beta0=29.5                agidl=4e-009+dagidln_hv18_snw
+ bgidl=8e+009+dbgidln_hv18_snw                       cgidl=21.599
+ egidl=0.55661             aigbacc=0.01238           bigbacc=0.006109
+ cigbacc=0.2809            nigbacc=4.05              aigbinv=0.02
+ bigbinv=0.02              cigbinv=0.006             eigbinv=1.1
+ nigbinv=1                 aigc=0.009898             bigc=0.001383
+ cigc=1.515e-005           aigsd=0.0086              bigsd=0.0004353
+ cigsd=3.925e-020          nigc=1                    poxedge=1
+ pigcd=1.672               ntox=1                    xrcrg1=12
+ xrcrg2=1                  cgso=cgson_hv18_snw       cgdo=cgdon_hv18_snw
+ cgbo=0                    cgdl=cgdln_hv18_snw       cgsl=cgsln_hv18_snw
+ clc=1e-007                cle=0.6                   cf=cfn_hv18_snw
+ ckappas=0.6               ckappad=0.6               acde=0.3
+ moin=5.2                  noff=2.9337               voffcv=-0.16925
+ tvoff=0.001               ltvoff=0                  wtvoff=0
+ ptvoff=0                  kt1=-0.39619656+dkt1n_hv18_snw
+ lkt1=4.44469e-008+dlkt1n_hv18_snw                   wkt1=2.8871456e-006+dwkt1n_hv18_snw
+ pkt1=-9.197266e-013+dpkt1n_hv18_snw                 kt1l=0
+ kt2=-0.028219541          lkt2=-1.197963e-008       wkt2=-2.7983458e-007
+ pkt2=1.634859e-013        ute=-1.35                 ua1=-5.6551155e-009
+ lua1=2.9152357e-015       wua1=4.8196155e-014       pua1=-1.8295076e-020
+ ub1=1.2830552e-017        lub1=-5.2706699e-024      wub1=-1.3581172e-022
+ pub1=4.8984203e-029       uc1=1.0637048e-010        luc1=2.9899484e-017
+ wuc1=6.5211032e-015       puc1=-2.5141878e-021      prt=0
+ at=-200000+datn_hv18_snw  jss=5.23e-007             jsws=2.52e-013
+ jswgs=2.52e-013           njs=1.02                  njd=1.02
+ ijthsfwd=0.01             ijthdfwd=0.01             ijthsrev=0.01
+ ijthdrev=0.01             bvs=8.4                   xjbvs=1
+ xjbvd=1                   jsd=1.03e-006             jswd=1.14e-012
+ jswgd=1.14e-012           bvd=14.1                  jtsswgs=3e-009+djtsswgsn_hv18_snw
+ jtsswgd=6e-008+djtsswgdn_hv18_snw                   njtsswg=20+dnjtsswgn_hv18_snw
+ xtsswgs=0.1               xtsswgd=0.75              tnjtsswg=0.5
+ vtsswgs=0.7               vtsswgd=0.05              pbs=0.5
+ cjs=cjsn_hv18_snw         mjs=0.24                  pbsws=0.3
+ cjsws=cjswsn_hv18_snw     mjsws=0.013               pbswgs=0.5
+ cjswgs=cjswgsn_hv18_snw   mjswgs=0.3                pbd=0.56
+ cjd=cjdn_hv18_snw         mjd=0.36                  pbswd=0.8
+ cjswd=cjswdn_hv18_snw     mjswd=0.31                pbswgd=0.8
+ cjswgd=cjswgdn_hv18_snw   mjswgd=0.36               tpb=0.002
+ tcj=0.0018                tpbsw=0.0025              tcjsw=0.0011
+ tpbswg=0.0028             tcjswg=0.00157            xtis=3
+ xtid=3                    dmcg=6.4e-08              dmci=6.4e-08
+ dmdg=0                    dmcgt=0                   dwj=0
+ xgw=0                     xgl=-1.09e-08             rshg=15.6
+ gbmin=1e-012              rbpb=50                   rbpd=50
+ rbps=50                   rbdb=50                   rbsb=50
+ ngcon=1                   wnfactor=0+dwnfactorn_hv18_snw
+ lnfactor=0+dlnfactorn_hv18_snw                      pnfactor=0+dpnfactorn_hv18_snw
+ weta0=0+dweta0n_hv18_snw  lat=0+dlatn_hv18_snw      wat=0+dwatn_hv18_snw
+ pat=0+dpatn_hv18_snw      lagidl=0+dlagidln_hv18_snw
+ wagidl=0+dwagidln_hv18_snw                          pagidl=0+dpagidln_hv18_snw
+ lbgidl=0+dlbgidln_hv18_snw                          wbgidl=0+dwbgidln_hv18_snw
+ pbgidl=0+dpbgidln_hv18_snw                          minr=1e-3

     11: type=n
+ lmin=1e-005-dxln_hv18_snw lmax=900.001e-06          wmin=1e-006-dxwn_hv18_snw
+ wmax=1e-005-dxwn_hv18_snw version=4.5               binunit=2
+ paramchk=1                mobmod=0                  capmod=2
+ igcmod=0                  igbmod=0                  diomod=1
+ rdsmod=1                  rbodymod=0                rgeomod=1
+ rgatemod=1*rgflag_hv18_snw_spw                      permod=1
+ acnqsmod=0                trnqsmod=0                tempmod=0
+ tnom=25                   toxe=toxn_hv18_snw        toxm=3.58e-009
+ dtox=2.7936e-010          epsrox=3.9                wint=0
+ lint=2.45e-007            ll=0                      wl=0
+ lln=1                     wln=1                     lw=0
+ ww=0                      lwn=1                     wwn=1
+ lwl=0                     wwl=0                     llc=0
+ wlc=0                     lwc=0                     wwc=0
+ lwlc=0                    wwlc=0                    xl=1e-08+dxln_hv18_snw
+ xw=0+dxwn_hv18_snw        dlc=ddlcn_hv18_snw        dwc=0
+ xpart=1                   toxref=3e-009             dlcig=2.5e-009
+ vth0=0.55545886+dvthn_hv18_snw                      wvth0=3.3111333e-009+dwvthn_hv18_snw
+ k1=0.24874                k2=0.064604332+dk2n_hv18_snw
+ wk2=-1.5533322e-009+dwk2n_hv18_snw                  k3=-1.82
+ k3b=1.0692                w0=0                      dvt0=1.1319
+ dvt1=0.0055               dvt2=0.00050391           dvt0w=0
+ dvt1w=0                   dvt2w=0                   dsub=0.25
+ minv=-0.4444              voffl=-5e-009             dvtp0=2.1516e-007
+ dvtp1=0.01                lpe0=5e-007               lpeb=2.4075e-007
+ xj=6.7e-008               ngate=8.5997e+020         ndep=9e+017
+ nsd=1e+020                phin=0.185                cdsc=0
+ cdscb=0                   cdscd=0                   cit=0.00037663752+dcitn_hv18_snw
+ wcit=-2.3697776e-010+dwcitn_hv18_snw                voff=-0.16090446+dvoffn_hv18_snw
+ wvoff=-1.2055556e-008+dwvoffn_hv18_snw              nfactor=0.6+dnfactorn_hv18_snw
+ eta0=0.0010241+deta0n_hv18_snw                      etab=-0.016263839
+ wetab=-3.1784433e-008     ud=0                      lud=0
+ wud=0                     pud=0                     u0=0.031800554+du0n_hv18_snw
+ wu0=-2.6555556e-010+dwu0n_hv18_snw                  ua=-7.1168214e-010
+ wua=-7.2577922e-017       ub=1.9813e-018            wub=-7e-027
+ uc=1.0850266e-010         wuc=-1.5926632e-017       vsat=160000+dvsatn_hv18_snw
+ a0=1.9104129+da0n_hv18_snw                          wa0=2.3188878e-007+dwa0n_hv18_snw
+ ags=0.63962001+dagsn_hv18_snw                       wags=-1.45e-008+dwagsn_hv18_snw
+ a1=0                      a2=1                      b0=0
+ b1=0                      keta=-0.053121889         wketa=-2.2111111e-010
+ dwg=0                     dwb=0                     pclm=0.014996
+ pdiblc1=0                 pdiblc2=0.0001            pdiblcb=0
+ drout=0.56                pvag=0.45                 delta=0.01
+ pscbe1=9.264e+008         pscbe2=1e-020             fprout=100
+ pdits=0                   pditsd=0                  pditsl=0
+ rsh=17.5                  rsw=65.35                 rdw=600
+ prwg=0                    prwb=0                    wr=1
+ alpha0=6.3669e-08         alpha1=1.5                beta0=29.5
+ agidl=3.3333333e-009+dagidln_hv18_snw               wagidl=6.6666667e-015+dwagidln_hv18_snw
+ bgidl=8e+009+dbgidln_hv18_snw                       cgidl=21.599
+ egidl=0.55661             aigbacc=0.01238           bigbacc=0.006109
+ cigbacc=0.2809            nigbacc=4.05              aigbinv=0.02
+ bigbinv=0.02              cigbinv=0.006             eigbinv=1.1
+ nigbinv=1                 aigc=0.009898             bigc=0.001383
+ cigc=1.515e-005           aigsd=0.0086              bigsd=0.0004353
+ cigsd=3.925e-020          nigc=1                    poxedge=1
+ pigcd=1.672               ntox=1                    xrcrg1=12
+ xrcrg2=1                  cgso=cgson_hv18_snw       cgdo=cgdon_hv18_snw
+ cgbo=0                    cgdl=cgdln_hv18_snw       cgsl=cgsln_hv18_snw
+ clc=1e-007                cle=0.6                   cf=cfn_hv18_snw
+ ckappas=0.6               ckappad=0.6               acde=0.3
+ moin=5.2                  noff=2.9337               voffcv=-0.16925
+ tvoff=0.001               ltvoff=0                  wtvoff=0
+ ptvoff=0                  kt1=-0.20114889+dkt1n_hv18_snw
+ wkt1=2.2888889e-009+dwkt1n_hv18_snw                 kt1l=0
+ kt2=-0.044091667          wkt2=-5.0553333e-008      ute=-1.35
+ ua1=6.5848555e-010        wua1=5.5344456e-017       ub1=-6.1661e-019
+ wub1=-1.337e-025          uc1=1.2902333e-010        wuc1=1.5156667e-016
+ prt=0                     at=6.1207342e-005+datn_hv18_snw
+ jss=5.23e-007             jsws=2.52e-013            jswgs=2.52e-013
+ njs=1.02                  njd=1.02                  ijthsfwd=0.01
+ ijthdfwd=0.01             ijthsrev=0.01             ijthdrev=0.01
+ bvs=8.4                   xjbvs=1                   xjbvd=1
+ jsd=1.03e-006             jswd=1.14e-012            jswgd=1.14e-012
+ bvd=14.1                  jtsswgs=3e-009+djtsswgsn_hv18_snw
+ jtsswgd=6e-008+djtsswgdn_hv18_snw                   njtsswg=20+dnjtsswgn_hv18_snw
+ xtsswgs=0.1               xtsswgd=0.75              tnjtsswg=0.5
+ vtsswgs=0.7               vtsswgd=0.05              pbs=0.5
+ cjs=cjsn_hv18_snw         mjs=0.24                  pbsws=0.3
+ cjsws=cjswsn_hv18_snw     mjsws=0.013               pbswgs=0.5
+ cjswgs=cjswgsn_hv18_snw   mjswgs=0.3                pbd=0.56
+ cjd=cjdn_hv18_snw         mjd=0.36                  pbswd=0.8
+ cjswd=cjswdn_hv18_snw     mjswd=0.31                pbswgd=0.8
+ cjswgd=cjswgdn_hv18_snw   mjswgd=0.36               tpb=0.002
+ tcj=0.0018                tpbsw=0.0025              tcjsw=0.0011
+ tpbswg=0.0028             tcjswg=0.00157            xtis=3
+ xtid=3                    dmcg=6.4e-08              dmci=6.4e-08
+ dmdg=0                    dmcgt=0                   dwj=0
+ xgw=0                     xgl=-1.09e-08             rshg=15.6
+ gbmin=1e-012              rbpb=50                   rbpd=50
+ rbps=50                   rbdb=50                   rbsb=50
+ ngcon=1                   lvth0=0+dlvthn_hv18_snw   pvth0=0+dpvthn_hv18_snw
+ lu0=0+dlu0n_hv18_snw      pu0=0+dpu0n_hv18_snw      la0=0+dla0n_hv18_snw
+ pa0=0+dpa0n_hv18_snw      lags=0+dlagsn_hv18_snw    pags=0+dpagsn_hv18_snw
+ lvsat=0+dlvsatn_hv18_snw  wnfactor=0+dwnfactorn_hv18_snw
+ lnfactor=0+dlnfactorn_hv18_snw                      pnfactor=0+dpnfactorn_hv18_snw
+ pvsat=0+dpvsatn_hv18_snw  wvsat=0+dwvsatn_hv18_snw  lk2=0+dlk2n_hv18_snw
+ pk2=0+dpk2n_hv18_snw      weta0=0+dweta0n_hv18_snw  lcit=0+dlcitn_hv18_snw
+ pcit=0+dpcitn_hv18_snw    lvoff=0+dlvoffn_hv18_snw  pvoff=0+dpvoffn_hv18_snw
+ lkt1=0+dlkt1n_hv18_snw    pkt1=0+dpkt1n_hv18_snw    lat=0+dlatn_hv18_snw
+ wat=0+dwatn_hv18_snw      pat=0+dpatn_hv18_snw      lagidl=0+dlagidln_hv18_snw
+ pagidl=0+dpagidln_hv18_snw                          lbgidl=0+dlbgidln_hv18_snw
+ wbgidl=0+dwbgidln_hv18_snw                          pbgidl=0+dpbgidln_hv18_snw
+ minr=1e-3

     12: type=n
+ lmin=1e-006-dxln_hv18_snw lmax=1e-005-dxln_hv18_snw wmin=1e-006-dxwn_hv18_snw
+ wmax=1e-005-dxwn_hv18_snw version=4.5               binunit=2
+ paramchk=1                mobmod=0                  capmod=2
+ igcmod=0                  igbmod=0                  diomod=1
+ rdsmod=1                  rbodymod=0                rgeomod=1
+ rgatemod=1*rgflag_hv18_snw_spw                      permod=1
+ acnqsmod=0                trnqsmod=0                tempmod=0
+ tnom=25                   toxe=toxn_hv18_snw        toxm=3.58e-009
+ dtox=2.7936e-010          epsrox=3.9                wint=0
+ lint=2.45e-007            ll=0                      wl=0
+ lln=1                     wln=1                     lw=0
+ ww=0                      lwn=1                     wwn=1
+ lwl=0                     wwl=0                     llc=0
+ wlc=0                     lwc=0                     wwc=0
+ lwlc=0                    wwlc=0                    xl=1e-08+dxln_hv18_snw
+ xw=0+dxwn_hv18_snw        dlc=ddlcn_hv18_snw        dwc=0
+ xpart=1                   toxref=3e-009             dlcig=2.5e-009
+ vth0=0.55304383+dvthn_hv18_snw                      lvth0=2.2991252e-008+dlvthn_hv18_snw
+ wvth0=4.5469246e-009+dwvthn_hv18_snw                pvth0=-1.1764857e-014+dpvthn_hv18_snw
+ k1=0.24874                k2=0.0639195+dk2n_hv18_snw
+ lk2=6.5196735e-009+dlk2n_hv18_snw                   wk2=-9.4205006e-010+dwk2n_hv18_snw
+ pk2=-5.8194673e-015+dpk2n_hv18_snw                  k3=-1.82
+ k3b=1.0692                w0=0                      dvt0=1.1319
+ dvt1=0.0055               dvt2=0.00050391           dvt0w=0
+ dvt1w=0                   dvt2w=0                   dsub=0.25
+ minv=-0.44444622          lminv=4.4003529e-010      voffl=-5e-009
+ dvtp0=2.1516e-007         dvtp1=0.01                lpe0=5e-007
+ lpeb=2.4075e-007          xj=6.7e-008               ngate=8.5997e+020
+ ndep=9e+017               nsd=1e+020                phin=0.185
+ cdsc=0                    cdscb=0                   cdscd=0
+ cit=0.0003498284+dcitn_hv18_snw                     lcit=2.552255e-010+dlcitn_hv18_snw
+ wcit=-2.3422821e-010+dwcitn_hv18_snw                pcit=-2.6175988e-017+dpcitn_hv18_snw
+ voff=-0.16184097+dvoffn_hv18_snw                    lvoff=8.9156149e-009+dlvoffn_hv18_snw
+ wvoff=-1.2893966e-008+dwvoffn_hv18_snw              pvoff=7.9817512e-015+dpvoffn_hv18_snw
+ nfactor=0.6+dnfactorn_hv18_snw                      eta0=0.0010241+deta0n_hv18_snw
+ etab=-0.016263839         wetab=-3.1784433e-008     ud=0
+ lud=0                     wud=0                     pud=0
+ u0=0.031118469+du0n_hv18_snw                        lu0=6.4935163e-009+dlu0n_hv18_snw
+ wu0=-2.7916528e-010+dwu0n_hv18_snw                  pu0=1.2956595e-016+dpu0n_hv18_snw
+ ua=-7.0796944e-010        lua=-3.5345269e-017       wua=-1.0962399e-016
+ pua=3.5268224e-022        ub=1.8938671e-018         lub=8.3236953e-025
+ wub=7.2199614e-026        pub=-7.5398824e-031       uc=9.511547e-011
+ luc=1.2744742e-016        wuc=-6.0675398e-018       puc=-9.3859546e-023
+ vsat=157817.31+dvsatn_hv18_snw                      lvsat=0.020779444+dlvsatn_hv18_snw
+ wvsat=0.0016049204+dwvsatn_hv18_snw                 pvsat=-1.5279003e-008+dpvsatn_hv18_snw
+ a0=2.0908735+da0n_hv18_snw-0.0317777*ff_flag_hv18_snw_spw+0.0317777*ss_flag_hv18_snw_spw
+ la0=-1.7180026e-006+dla0n_hv18_snw+3.02524e-07*ff_flag_hv18_snw_spw-3.02524e-07*ss_flag_hv18_snw_spw
+ wa0=2.2265085e-007+dwa0n_hv18_snw-4.2e-14*ff_flag_hv18_snw_spw+4.2e-14*ss_flag_hv18_snw_spw
+ pa0=8.7946015e-014+dpa0n_hv18_snw+2.7e-19*ff_flag_hv18_snw_spw-2.7e-19*ss_flag_hv18_snw_spw
+ ags=0.66547727+dagsn_hv18_snw+0.0237531*ff_flag_hv18_snw_spw-0.0173334*ss_flag_hv18_snw_spw
+ lags=-2.4616368e-007+dlagsn_hv18_snw-2.26129e-07*ff_flag_hv18_snw_spw+1.65013e-07*ss_flag_hv18_snw_spw
+ wags=-1.4132794e-008+dwagsn_hv18_snw-6.41974e-09*ff_flag_hv18_snw_spw+4.1e-14*ss_flag_hv18_snw_spw
+ pags=-3.4958359e-015+dpagsn_hv18_snw+6.11158e-14*ff_flag_hv18_snw_spw+1.5e-19*ss_flag_hv18_snw_spw
+ a1=0                      a2=1                      b0=0
+ b1=0                      keta=-0.049931724         lketa=-3.0370685e-008
+ wketa=-1.0814126e-009     pketa=8.1901562e-015      dwg=0
+ dwb=0                     pclm=0.015252787          lpclm=-2.4446405e-009
+ wpclm=-2.5678727e-010     ppclm=2.4446405e-015      pdiblc1=0
+ pdiblc2=0.0001            pdiblcb=0                 drout=0.56
+ pvag=0.45                 delta=0.01                pscbe1=9.264e+008
+ pscbe2=1e-020             fprout=100                pdits=0
+ pditsd=0                  pditsl=0                  rsh=17.5
+ rsw=65.35                 rdw=600                   prwg=0
+ prwb=0                    wr=1                      alpha0=6.3669e-08
+ alpha1=1.5                beta0=29.5                agidl=3.3333333e-009+dagidln_hv18_snw
+ wagidl=6.6666667e-015+dwagidln_hv18_snw             bgidl=8e+009+dbgidln_hv18_snw
+ cgidl=21.599              egidl=0.55661             aigbacc=0.01238
+ bigbacc=0.006109          cigbacc=0.2809            nigbacc=4.05
+ aigbinv=0.02              bigbinv=0.02              cigbinv=0.006
+ eigbinv=1.1               nigbinv=1                 aigc=0.009898
+ bigc=0.001383             cigc=1.515e-005           aigsd=0.0086
+ bigsd=0.0004353           cigsd=3.925e-020          nigc=1
+ poxedge=1                 pigcd=1.672               ntox=1
+ xrcrg1=12                 xrcrg2=1                  cgso=cgson_hv18_snw
+ cgdo=cgdon_hv18_snw       cgbo=0                    cgdl=cgdln_hv18_snw
+ cgsl=cgsln_hv18_snw       clc=1e-007                cle=0.6
+ cf=cfn_hv18_snw           ckappas=0.6               ckappad=0.6
+ acde=0.3                  moin=5.2                  noff=2.9337
+ voffcv=-0.16925           tvoff=0.001               ltvoff=0
+ wtvoff=0                  ptvoff=0                  kt1=-0.19834233+dkt1n_hv18_snw
+ lkt1=-2.6718698e-008+dlkt1n_hv18_snw                wkt1=1.8696837e-009+dwkt1n_hv18_snw
+ pkt1=3.9908756e-015+dpkt1n_hv18_snw                 kt1l=0
+ kt2=-0.042794455          lkt2=-1.234959e-008       wkt2=-5.3331258e-008
+ pkt2=2.6446121e-014       ute=-1.35                 ua1=5.3683689e-010
+ lua1=1.1581075e-015       wua1=1.405086e-016        pua1=-8.1077114e-022
+ ub1=-4.7686824e-019       lub1=-1.3303556e-024      wub1=-2.5896918e-025
+ pub1=1.1925751e-030       uc1=1.2844043e-010        luc1=5.5493339e-018
+ wuc1=1.5844728e-016       puc1=-6.5504142e-023      prt=0
+ at=11555.427+datn_hv18_snw                          lat=-0.11000882+dlatn_hv18_snw
+ jss=5.23e-007             jsws=2.52e-013            jswgs=2.52e-013
+ njs=1.02                  njd=1.02                  ijthsfwd=0.01
+ ijthdfwd=0.01             ijthsrev=0.01             ijthdrev=0.01
+ bvs=8.4                   xjbvs=1                   xjbvd=1
+ jsd=1.03e-006             jswd=1.14e-012            jswgd=1.14e-012
+ bvd=14.1                  jtsswgs=3e-009+djtsswgsn_hv18_snw
+ jtsswgd=6e-008+djtsswgdn_hv18_snw                   njtsswg=20+dnjtsswgn_hv18_snw
+ xtsswgs=0.1               xtsswgd=0.75              tnjtsswg=0.5
+ vtsswgs=0.7               vtsswgd=0.05              pbs=0.5
+ cjs=cjsn_hv18_snw         mjs=0.24                  pbsws=0.3
+ cjsws=cjswsn_hv18_snw     mjsws=0.013               pbswgs=0.5
+ cjswgs=cjswgsn_hv18_snw   mjswgs=0.3                pbd=0.56
+ cjd=cjdn_hv18_snw         mjd=0.36                  pbswd=0.8
+ cjswd=cjswdn_hv18_snw     mjswd=0.31                pbswgd=0.8
+ cjswgd=cjswgdn_hv18_snw   mjswgd=0.36               tpb=0.002
+ tcj=0.0018                tpbsw=0.0025              tcjsw=0.0011
+ tpbswg=0.0028             tcjswg=0.00157            xtis=3
+ xtid=3                    dmcg=6.4e-08              dmci=6.4e-08
+ dmdg=0                    dmcgt=0                   dwj=0
+ xgw=0                     xgl=-1.09e-08             rshg=15.6
+ gbmin=1e-012              rbpb=50                   rbpd=50
+ rbps=50                   rbdb=50                   rbsb=50
+ ngcon=1                   wnfactor=0+dwnfactorn_hv18_snw
+ lnfactor=0+dlnfactorn_hv18_snw                      pnfactor=0+dpnfactorn_hv18_snw
+ weta0=0+dweta0n_hv18_snw  wat=0+dwatn_hv18_snw      pat=0+dpatn_hv18_snw
+ lagidl=0+dlagidln_hv18_snw                          pagidl=0+dpagidln_hv18_snw
+ lbgidl=0+dlbgidln_hv18_snw                          wbgidl=0+dwbgidln_hv18_snw
+ pbgidl=0+dpbgidln_hv18_snw                          minr=1e-3

     13: type=n
+ lmin=9e-007-dxln_hv18_snw lmax=1e-006-dxln_hv18_snw wmin=1e-006-dxwn_hv18_snw
+ wmax=1e-005-dxwn_hv18_snw version=4.5               binunit=2
+ paramchk=1                mobmod=0                  capmod=2
+ igcmod=0                  igbmod=0                  diomod=1
+ rdsmod=1                  rbodymod=0                rgeomod=1
+ rgatemod=1*rgflag_hv18_snw_spw                      permod=1
+ acnqsmod=0                trnqsmod=0                tempmod=0
+ tnom=25                   toxe=toxn_hv18_snw        toxm=3.58e-009
+ dtox=2.7936e-010          epsrox=3.9                wint=0
+ lint=2.45e-007            ll=0                      wl=0
+ lln=1                     wln=1                     lw=0
+ ww=0                      lwn=1                     wwn=1
+ lwl=0                     wwl=0                     llc=0
+ wlc=0                     lwc=0                     wwc=0
+ lwlc=0                    wwlc=0                    xl=1e-08+dxln_hv18_snw
+ xw=0+dxwn_hv18_snw        dlc=ddlcn_hv18_snw        dwc=0
+ xpart=1                   toxref=3e-009             dlcig=2.5e-009
+ vth0=0.53626446+dvthn_hv18_snw                      lvth0=3.1716529e-008+dlvthn_hv18_snw
+ wvth0=-3.352456e-008+dwvthn_hv18_snw                pvth0=8.0323152e-015+dpvthn_hv18_snw
+ k1=0.24874                k2=0.095829605+dk2n_hv18_snw
+ lk2=-1.0073581e-008+dlk2n_hv18_snw                  wk2=-4.1846005e-008+dwk2n_hv18_snw
+ pk2=1.5450589e-014+dpk2n_hv18_snw                   k3=-1.82
+ k3b=1.0692                w0=0                      dvt0=1.1319
+ dvt1=0.0055               dvt2=0.00050391           dvt0w=0
+ dvt1w=0                   dvt2w=0                   dsub=0.25
+ minv=-0.4436              voffl=-5e-009             dvtp0=2.1516e-007
+ dvtp1=0.01                lpe0=5e-007               lpeb=2.4075e-007
+ xj=6.7e-008               ngate=8.5997e+020         ndep=9e+017
+ nsd=1e+020                phin=0.185                cdsc=0
+ cdscb=0                   cdscd=0                   cit=0.00023982698+dcitn_hv18_snw
+ lcit=3.1242624e-010+dlcitn_hv18_snw                 wcit=5.2318725e-010+dwcitn_hv18_snw
+ pcit=-4.2003202e-016+dpcitn_hv18_snw                voff=-0.18215022+dvoffn_hv18_snw
+ lvoff=1.9476427e-008+dlvoffn_hv18_snw               wvoff=3.8062222e-008+dwvoffn_hv18_snw
+ pvoff=-1.8515467e-014+dpvoffn_hv18_snw              nfactor=0.6+dnfactorn_hv18_snw
+ eta0=0.0010241+deta0n_hv18_snw                      etab=-0.016263839
+ wetab=-3.1784433e-008     ud=0                      lud=0
+ wud=0                     pud=0                     u0=0.043133733+du0n_hv18_snw
+ lu0=2.4557867e-010+dlu0n_hv18_snw                   wu0=3.0666667e-011+dwu0n_hv18_snw
+ pu0=-3.1546667e-017+dpu0n_hv18_snw                  ua=-6.6379154e-010
+ lua=-5.8317777e-017       wua=1.9070575e-015        pua=-6.9599212e-022
+ ub=2.6485111e-018         lub=4.3995467e-025        wub=-2.5099111e-024
+ pub=5.8870933e-031        uc=3.6280728e-010         luc=-1.1752325e-017
+ wuc=-3.1849333e-016       puc=6.8601867e-023        vsat=286444.49+dvsatn_hv18_snw
+ lvsat=-0.046106691+dlvsatn_hv18_snw                 wvsat=-0.074444491+dwvsatn_hv18_snw
+ pvsat=2.4266691e-008+dpvsatn_hv18_snw               a0=0.7781494+da0n_hv18_snw+1.88*ff_flag_hv18_snw_spw-2.23*ss_flag_hv18_snw_spw
+ la0=-1.0353861e-006+dla0n_hv18_snw-6.91603e-07*ff_flag_hv18_snw_spw+8.73603e-07*ss_flag_hv18_snw_spw
+ wa0=8.8831123e-007+dwa0n_hv18_snw-6.99997e-07*ff_flag_hv18_snw_spw+2e-12*ss_flag_hv18_snw_spw
+ pa0=-2.5819738e-013+dpa0n_hv18_snw+3.64003e-13*ff_flag_hv18_snw_spw-3e-18*ss_flag_hv18_snw_spw
+ ags=-0.0053748484+dagsn_hv18_snw-1.67111*ff_flag_hv18_snw_spw+1.09333*ss_flag_hv18_snw_spw
+ lags=1.0267942e-007+dlagsn_hv18_snw+6.552e-07*ff_flag_hv18_snw_spw-4.12533e-07*ss_flag_hv18_snw_spw
+ wags=-1.0614292e-006+dwagsn_hv18_snw+1.11107e-07*ff_flag_hv18_snw_spw+4.66673e-07*ss_flag_hv18_snw_spw
+ pags=5.410983e-013+dpagsn_hv18_snw+0.0*ff_flag_hv18_snw_spw-2.42667e-13*ss_flag_hv18_snw_spw
+ a1=0                      a2=1                      b0=0
+ b1=0                      keta=0.013717445          lketa=-6.3468254e-008
+ wketa=-1.2227445e-007     pketa=7.1210536e-014      dwg=0
+ dwb=0                     pclm=0.010551556          wpclm=4.4444444e-009
+ pdiblc1=0                 pdiblc2=0.00010000003     lpdiblc2=-1.4802667e-017
+ wpdiblc2=9.3333333e-017   ppdiblc2=-4.8533334e-023  pdiblcb=0
+ drout=0.56                pvag=0.45                 delta=0.01
+ pscbe1=9.264e+008         pscbe2=1e-020             fprout=100
+ pdits=0                   pditsd=0                  pditsl=0
+ rsh=17.5                  rsw=65.35                 rdw=600
+ prwg=0                    prwb=0                    wr=1
+ alpha0=6.3669e-08         alpha1=1.5                beta0=29.5
+ agidl=3.3333333e-009+dagidln_hv18_snw               wagidl=6.6666667e-015+dwagidln_hv18_snw
+ bgidl=8e+009+dbgidln_hv18_snw                       cgidl=21.599
+ egidl=0.55661             aigbacc=0.01238           bigbacc=0.006109
+ cigbacc=0.2809            nigbacc=4.05              aigbinv=0.02
+ bigbinv=0.02              cigbinv=0.006             eigbinv=1.1
+ nigbinv=1                 aigc=0.009898             bigc=0.001383
+ cigc=1.515e-005           aigsd=0.0086              bigsd=0.0004353
+ cigsd=3.925e-020          nigc=1                    poxedge=1
+ pigcd=1.672               ntox=1                    xrcrg1=12
+ xrcrg2=1                  cgso=cgson_hv18_snw       cgdo=cgdon_hv18_snw
+ cgbo=0                    cgdl=cgdln_hv18_snw       cgsl=cgsln_hv18_snw
+ clc=1e-007                cle=0.6                   cf=cfn_hv18_snw
+ ckappas=0.6               ckappad=0.6               acde=0.3
+ moin=5.2                  noff=2.9337               voffcv=-0.16925
+ tvoff=0.001               ltvoff=0                  wtvoff=0
+ ptvoff=0                  kt1=-0.21922778+dkt1n_hv18_snw
+ lkt1=-1.5858267e-008+dlkt1n_hv18_snw                wkt1=2.2937778e-008+dwkt1n_hv18_snw
+ pkt1=-6.9645333e-015+dpkt1n_hv18_snw                kt1l=0
+ kt2=-0.15187179           lkt2=4.4370627e-008       wkt2=-7.6720047e-009
+ pkt2=2.7033091e-015       ute=-1.35                 ua1=4.04352e-009
+ lua1=-6.6536773e-016      wua1=-6.0872e-015         pua1=2.4276373e-021
+ ub1=-6.5505035e-018       lub1=1.8279347e-024       wub1=9.131044e-024
+ pub1=-3.6902318e-030      uc1=3.3877651e-010        luc1=-1.0382543e-016
+ wuc1=1.5234101e-016       puc1=-6.232888e-023       prt=0
+ at=-200000+datn_hv18_snw  jss=5.23e-007             jsws=2.52e-013
+ jswgs=2.52e-013           njs=1.02                  njd=1.02
+ ijthsfwd=0.01             ijthdfwd=0.01             ijthsrev=0.01
+ ijthdrev=0.01             bvs=8.4                   xjbvs=1
+ xjbvd=1                   jsd=1.03e-006             jswd=1.14e-012
+ jswgd=1.14e-012           bvd=14.1                  jtsswgs=3e-009+djtsswgsn_hv18_snw
+ jtsswgd=6e-008+djtsswgdn_hv18_snw                   njtsswg=20+dnjtsswgn_hv18_snw
+ xtsswgs=0.1               xtsswgd=0.75              tnjtsswg=0.5
+ vtsswgs=0.7               vtsswgd=0.05              pbs=0.5
+ cjs=cjsn_hv18_snw         mjs=0.24                  pbsws=0.3
+ cjsws=cjswsn_hv18_snw     mjsws=0.013               pbswgs=0.5
+ cjswgs=cjswgsn_hv18_snw   mjswgs=0.3                pbd=0.56
+ cjd=cjdn_hv18_snw         mjd=0.36                  pbswd=0.8
+ cjswd=cjswdn_hv18_snw     mjswd=0.31                pbswgd=0.8
+ cjswgd=cjswgdn_hv18_snw   mjswgd=0.36               tpb=0.002
+ tcj=0.0018                tpbsw=0.0025              tcjsw=0.0011
+ tpbswg=0.0028             tcjswg=0.00157            xtis=3
+ xtid=3                    dmcg=6.4e-08              dmci=6.4e-08
+ dmdg=0                    dmcgt=0                   dwj=0
+ xgw=0                     xgl=-1.09e-08             rshg=15.6
+ gbmin=1e-012              rbpb=50                   rbpd=50
+ rbps=50                   rbdb=50                   rbsb=50
+ ngcon=1                   wnfactor=0+dwnfactorn_hv18_snw
+ lnfactor=0+dlnfactorn_hv18_snw                      pnfactor=0+dpnfactorn_hv18_snw
+ weta0=0+dweta0n_hv18_snw  lat=0+dlatn_hv18_snw      wat=0+dwatn_hv18_snw
+ pat=0+dpatn_hv18_snw      lagidl=0+dlagidln_hv18_snw
+ pagidl=0+dpagidln_hv18_snw                          lbgidl=0+dlbgidln_hv18_snw
+ wbgidl=0+dwbgidln_hv18_snw                          pbgidl=0+dpbgidln_hv18_snw
+ minr=1e-3

     14: type=n
+ lmin=8.5e-007-dxln_hv18_snw                         lmax=9e-007-dxln_hv18_snw
+ wmin=1e-006-dxwn_hv18_snw wmax=1e-005-dxwn_hv18_snw version=4.5
+ binunit=2                 paramchk=1                mobmod=0
+ capmod=2                  igcmod=0                  igbmod=0
+ diomod=1                  rdsmod=1                  rbodymod=0
+ rgeomod=1                 rgatemod=1*rgflag_hv18_snw_spw
+ permod=1                  acnqsmod=0                trnqsmod=0
+ tempmod=0                 tnom=25                   toxe=toxn_hv18_snw
+ toxm=3.58e-009            dtox=2.7936e-010          epsrox=3.9
+ wint=0                    lint=2.45e-007            ll=0
+ wl=0                      lln=1                     wln=1
+ lw=0                      ww=0                      lwn=1
+ wwn=1                     lwl=0                     wwl=0
+ llc=0                     wlc=0                     lwc=0
+ wwc=0                     lwlc=0                    wwlc=0
+ xl=1e-08+dxln_hv18_snw    xw=0+dxwn_hv18_snw        dlc=ddlcn_hv18_snw
+ dwc=0                     xpart=1                   toxref=3e-009
+ dlcig=2.5e-009            vth0=0.68846867+dvthn_hv18_snw
+ lvth0=-3.220924e-008+dlvthn_hv18_snw                wvth0=-1.3082667e-007+dwvthn_hv18_snw
+ pvth0=4.88992e-014+dpvthn_hv18_snw                  k1=0.24874
+ k2=0.1099598+dk2n_hv18_snw                          lk2=-1.6008265e-008+dlk2n_hv18_snw
+ wk2=-1.9834205e-008+dwk2n_hv18_snw                  pk2=6.2056331e-015+dpk2n_hv18_snw
+ k3=-1.82                  k3b=1.0692                w0=0
+ dvt0=1.1319               dvt1=0.0055               dvt2=0.00050391
+ dvt0w=0                   dvt1w=0                   dvt2w=0
+ dsub=0.25                 minv=-0.4436              voffl=-5e-009
+ dvtp0=2.1516e-007         dvtp1=0.01                lpe0=5e-007
+ lpeb=2.4075e-007          xj=6.7e-008               ngate=8.5997e+020
+ ndep=9e+017               nsd=1e+020                phin=0.185
+ cdsc=0                    cdscb=0                   cdscd=0
+ cit=0.0012044661+dcitn_hv18_snw                     lcit=-9.2722218e-011+dlcitn_hv18_snw
+ wcit=-1.8794364e-009+dwcitn_hv18_snw                pcit=5.8906991e-016+dpcitn_hv18_snw
+ voff=-0.24105511+dvoffn_hv18_snw                    lvoff=4.421648e-008+dlvoffn_hv18_snw
+ wvoff=1.8151111e-008+dwvoffn_hv18_snw               pvoff=-1.01528e-014+dpvoffn_hv18_snw
+ nfactor=0.6+dnfactorn_hv18_snw                      eta0=0.0010241+deta0n_hv18_snw
+ etab=-0.016263839         wetab=-3.1784433e-008     ud=0
+ lud=0                     wud=0                     pud=0
+ u0=0.044164911+du0n_hv18_snw                        lu0=-1.87516e-010+dlu0n_hv18_snw
+ wu0=-5.8711111e-010+dwu0n_hv18_snw                  pu0=2.2792e-016+dpu0n_hv18_snw
+ ua=-1.63382e-009          lua=3.4909419e-016        wua=1.783296e-015
+ pua=-6.4401231e-022       ub=3.5767178e-018         lub=5.0107867e-026
+ wub=-2.2091778e-024       pub=4.6240133e-031        uc=5.6457082e-010
+ luc=-9.6493009e-017       wuc=-2.2594889e-016       puc=2.97332e-023
+ vsat=242444.35+dvsatn_hv18_snw                      lvsat=-0.027626632+dlvsatn_hv18_snw
+ wvsat=-0.082444351+dwvsatn_hv18_snw                 pvsat=2.7626632e-008+dpvsatn_hv18_snw
+ a0=-0.19982074+da0n_hv18_snw+2.08333*ff_flag_hv18_snw_spw-0.947556*ss_flag_hv18_snw_spw
+ la0=-6.2463862e-007+dla0n_hv18_snw-7.77e-07*ff_flag_hv18_snw_spw+3.34973e-07*ss_flag_hv18_snw_spw
+ wa0=1.6146e-006+dwa0n_hv18_snw-3.53333e-06*ff_flag_hv18_snw_spw+5.75556e-07*ss_flag_hv18_snw_spw
+ pa0=-5.6323867e-013+dpa0n_hv18_snw+1.554e-12*ff_flag_hv18_snw_spw-2.41733e-13*ss_flag_hv18_snw_spw
+ ags=0.086223905+dagsn_hv18_snw-0.933333*ff_flag_hv18_snw_spw+0.933333*ss_flag_hv18_snw_spw
+ lags=6.4207944e-008+dlagsn_hv18_snw+3.45333e-07*ff_flag_hv18_snw_spw-3.45333e-07*ss_flag_hv18_snw_spw
+ wags=-8.3212157e-007+dwagsn_hv18_snw+9.33333e-07*ff_flag_hv18_snw_spw-9.33333e-07*ss_flag_hv18_snw_spw
+ pags=4.4478909e-013+dpagsn_hv18_snw-3.45333e-13*ff_flag_hv18_snw_spw+3.45333e-13*ss_flag_hv18_snw_spw
+ a1=0                      a2=1                      b0=0
+ b1=0                      keta=-0.27001531          lketa=5.5699504e-008
+ wketa=1.2137311e-007      pketa=-3.112144e-014      dwg=0
+ dwb=0                     pclm=-0.022337333         lpclm=1.3813333e-008
+ wpclm=3.7333333e-008      ppclm=-1.3813333e-014     pdiblc1=0
+ pdiblc2=0.00018222194     lpdiblc2=-3.4533219e-011  wpdiblc2=-8.2222241e-010
+ ppdiblc2=3.453334e-016    pdiblcb=0                 drout=0.56
+ pvag=0.45                 delta=0.01                pscbe1=9.264e+008
+ pscbe2=1e-020             fprout=100                pdits=0
+ pditsd=0                  pditsl=0                  rsh=17.5
+ rsw=65.35                 rdw=600                   prwg=0
+ prwb=0                    wr=1                      alpha0=6.3669e-08
+ alpha1=1.5                beta0=29.5                agidl=3.3333333e-009+dagidln_hv18_snw
+ wagidl=6.6666667e-015+dwagidln_hv18_snw             bgidl=8e+009+dbgidln_hv18_snw
+ cgidl=21.599              egidl=0.55661             aigbacc=0.01238
+ bigbacc=0.006109          cigbacc=0.2809            nigbacc=4.05
+ aigbinv=0.02              bigbinv=0.02              cigbinv=0.006
+ eigbinv=1.1               nigbinv=1                 aigc=0.009898
+ bigc=0.001383             cigc=1.515e-005           aigsd=0.0086
+ bigsd=0.0004353           cigsd=3.925e-020          nigc=1
+ poxedge=1                 pigcd=1.672               ntox=1
+ xrcrg1=12                 xrcrg2=1                  cgso=cgson_hv18_snw
+ cgdo=cgdon_hv18_snw       cgbo=0                    cgdl=cgdln_hv18_snw
+ cgsl=cgsln_hv18_snw       clc=1e-007                cle=0.6
+ cf=cfn_hv18_snw           ckappas=0.6               ckappad=0.6
+ acde=0.3                  moin=5.2                  noff=2.9337
+ voffcv=-0.16925           tvoff=0.001               ltvoff=0
+ wtvoff=0                  ptvoff=0                  kt1=-0.43253822+dkt1n_hv18_snw
+ lkt1=7.373212e-008+dlkt1n_hv18_snw                  wkt1=2.5080222e-007+dwkt1n_hv18_snw
+ pkt1=-1.026676e-013+dpkt1n_hv18_snw                 kt1l=0
+ kt2=-0.042718212          lkt2=-1.4738778e-009      wkt2=-1.8107196e-007
+ pkt2=7.5531289e-014       ute=-1.35                 ua1=5.5426441e-009
+ lua1=-1.2949999e-015      wua1=-6.7426412e-015      pua1=2.7029226e-021
+ ub1=-6.0843478e-018       lub1=1.6321494e-024       wub1=9.0800692e-024
+ pub1=-3.6688224e-030      uc1=-5.5686586e-010       luc1=2.7234436e-016
+ wuc1=1.4701671e-015       puc1=-6.1581585e-022      prt=0
+ at=-200000+datn_hv18_snw  jss=5.23e-007             jsws=2.52e-013
+ jswgs=2.52e-013           njs=1.02                  njd=1.02
+ ijthsfwd=0.01             ijthdfwd=0.01             ijthsrev=0.01
+ ijthdrev=0.01             bvs=8.4                   xjbvs=1
+ xjbvd=1                   jsd=1.03e-006             jswd=1.14e-012
+ jswgd=1.14e-012           bvd=14.1                  jtsswgs=3e-009+djtsswgsn_hv18_snw
+ jtsswgd=6e-008+djtsswgdn_hv18_snw                   njtsswg=20+dnjtsswgn_hv18_snw
+ xtsswgs=0.1               xtsswgd=0.75              tnjtsswg=0.5
+ vtsswgs=0.7               vtsswgd=0.05              pbs=0.5
+ cjs=cjsn_hv18_snw         mjs=0.24                  pbsws=0.3
+ cjsws=cjswsn_hv18_snw     mjsws=0.013               pbswgs=0.5
+ cjswgs=cjswgsn_hv18_snw   mjswgs=0.3                pbd=0.56
+ cjd=cjdn_hv18_snw         mjd=0.36                  pbswd=0.8
+ cjswd=cjswdn_hv18_snw     mjswd=0.31                pbswgd=0.8
+ cjswgd=cjswgdn_hv18_snw   mjswgd=0.36               tpb=0.002
+ tcj=0.0018                tpbsw=0.0025              tcjsw=0.0011
+ tpbswg=0.0028             tcjswg=0.00157            xtis=3
+ xtid=3                    dmcg=6.4e-08              dmci=6.4e-08
+ dmdg=0                    dmcgt=0                   dwj=0
+ xgw=0                     xgl=-1.09e-08             rshg=15.6
+ gbmin=1e-012              rbpb=50                   rbpd=50
+ rbps=50                   rbdb=50                   rbsb=50
+ ngcon=1                   wnfactor=0+dwnfactorn_hv18_snw
+ lnfactor=0+dlnfactorn_hv18_snw                      pnfactor=0+dpnfactorn_hv18_snw
+ weta0=0+dweta0n_hv18_snw  lat=0+dlatn_hv18_snw      wat=0+dwatn_hv18_snw
+ pat=0+dpatn_hv18_snw      lagidl=0+dlagidln_hv18_snw
+ pagidl=0+dpagidln_hv18_snw                          lbgidl=0+dlbgidln_hv18_snw
+ wbgidl=0+dwbgidln_hv18_snw                          pbgidl=0+dpbgidln_hv18_snw
+ minr=1e-3

     15: type=n
+ lmin=0.792e-06            lmax=8.5e-007-dxln_hv18_snw
+ wmin=1e-006-dxwn_hv18_snw wmax=1e-005-dxwn_hv18_snw version=4.5
+ binunit=2                 paramchk=1                mobmod=0
+ capmod=2                  igcmod=0                  igbmod=0
+ diomod=1                  rdsmod=1                  rbodymod=0
+ rgeomod=1                 rgatemod=1*rgflag_hv18_snw_spw
+ permod=1                  acnqsmod=0                trnqsmod=0
+ tempmod=0                 tnom=25                   toxe=toxn_hv18_snw
+ toxm=3.58e-009            dtox=2.7936e-010          epsrox=3.9
+ wint=0                    lint=2.45e-007            ll=0
+ wl=0                      lln=1                     wln=1
+ lw=0                      ww=0                      lwn=1
+ wwn=1                     lwl=0                     wwl=0
+ llc=0                     wlc=0                     lwc=0
+ wwc=0                     lwlc=0                    wwlc=0
+ xl=1e-08+dxln_hv18_snw    xw=0+dxwn_hv18_snw        dlc=ddlcn_hv18_snw
+ dwc=0                     xpart=1                   toxref=3e-009
+ dlcig=2.5e-009            vth0=0.58711622+dvthn_hv18_snw
+ lvth0=5.2911644e-009+dlvthn_hv18_snw                wvth0=-2.2062222e-008+dwvthn_hv18_snw
+ pvth0=8.6563556e-015+dpvthn_hv18_snw                k1=0.24874
+ k2=0.10207201+dk2n_hv18_snw                         lk2=-1.3089781e-008+dlk2n_hv18_snw
+ wk2=1.0775985e-008+dwk2n_hv18_snw                   pk2=-5.120137e-015+dpk2n_hv18_snw
+ k3=-1.82                  k3b=1.0692                w0=0
+ dvt0=1.1319               dvt1=0.0055               dvt2=0.00050391
+ dvt0w=0                   dvt1w=0                   dvt2w=0
+ dsub=0.25                 minv=-0.43791111          lminv=-2.1048889e-009
+ wminv=-5.6888889e-009     pminv=2.1048889e-015      voffl=-5e-009
+ dvtp0=2.1516e-007         dvtp1=0.01                lpe0=5e-007
+ lpeb=2.4075e-007          xj=6.7e-008               ngate=8.5997e+020
+ ndep=9e+017               nsd=1e+020                phin=0.185
+ cdsc=0                    cdscb=0                   cdscd=0
+ cit=0.00049206297+dcitn_hv18_snw                    lcit=1.7086696e-010+dlcitn_hv18_snw
+ wcit=-7.2980897e-010+dwcitn_hv18_snw                pcit=1.6370776e-016+dpcitn_hv18_snw
+ voff=-0.11246311+dvoffn_hv18_snw                    lvoff=-3.36256e-009+dlvoffn_hv18_snw
+ wvoff=-5.4488889e-009+dwvoffn_hv18_snw              pvoff=-1.4208e-015+dpvoffn_hv18_snw
+ nfactor=0.6+dnfactorn_hv18_snw                      eta0=0.0010241+deta0n_hv18_snw
+ etab=-0.016263839         wetab=-3.1784433e-008     ud=0
+ lud=0                     wud=0                     pud=0
+ u0=0.042029667+du0n_hv18_snw                        lu0=6.0252444e-010+dlu0n_hv18_snw
+ wu0=1.0173333e-009+dwu0n_hv18_snw                   pu0=-3.6572444e-016+dpu0n_hv18_snw
+ ua=-2.3580844e-010        lua=-1.681701e-016        wua=-6.4641556e-016
+ pua=2.5498098e-022        ub=9.4791333e-019         lub=1.0227655e-024
+ wub=2.1132667e-024        pub=-1.1369031e-030       uc=6.815283e-010
+ luc=-1.3976728e-016       wuc=-2.0532229e-016       puc=2.210136e-023
+ vsat=217555.56+dvsatn_hv18_snw                      lvsat=-0.018417778+dlvsatn_hv18_snw
+ wvsat=-0.057555556+dwvsatn_hv18_snw                 pvsat=1.8417778e-008+dpvsatn_hv18_snw
+ a0=1.9988297+da0n_hv18_snw+2.72112*ff_flag_hv18_snw_spw-1.37911*ss_flag_hv18_snw_spw
+ la0=-1.4381393e-006+dla0n_hv18_snw-1.01298e-06*ff_flag_hv18_snw_spw+4.9465e-07*ss_flag_hv18_snw_spw
+ wa0=6.029104e-007+dwa0n_hv18_snw+2.08888e-06*ff_flag_hv18_snw_spw+4.91113e-07*ss_flag_hv18_snw_spw
+ pa0=-1.8891351e-013+dpa0n_hv18_snw-5.26222e-13*ff_flag_hv18_snw_spw-2.1049e-13*ss_flag_hv18_snw_spw
+ ags=-0.39604911+dagsn_hv18_snw                      lags=2.4264896e-007+dlagsn_hv18_snw
+ wags=-4.8374889e-007+dwagsn_hv18_snw                pags=3.158912e-013+dpagsn_hv18_snw
+ a1=0                      a2=1                      b0=0
+ b1=0                      keta=-0.13259682          lketa=4.8546631e-009
+ wketa=-1.6625178e-007     pketa=7.5299769e-014      dwg=0
+ dwb=0                     pclm=0.014998844          lpclm=-1.0524444e-012
+ wpclm=-2.8444444e-011     ppclm=1.0524444e-017      pdiblc1=0
+ pdiblc2=-0.001262222      lpdiblc2=4.9991103e-010   wpdiblc2=8.2222187e-010
+ ppdiblc2=-2.6311098e-016  pdiblcb=0                 drout=0.56
+ pvag=0.45                 delta=0.01                pscbe1=9.264e+008
+ pscbe2=1e-020             fprout=100                pdits=0
+ pditsd=0                  pditsl=0                  rsh=17.5
+ rsw=65.35                 rdw=600                   prwg=0
+ prwb=0                    wr=1                      alpha0=6.3669e-08
+ alpha1=1.5                beta0=29.5                agidl=3.3333333e-009+dagidln_hv18_snw
+ wagidl=6.6666667e-015+dwagidln_hv18_snw             bgidl=8e+009+dbgidln_hv18_snw
+ cgidl=21.599              egidl=0.55661             aigbacc=0.01238
+ bigbacc=0.006109          cigbacc=0.2809            nigbacc=4.05
+ aigbinv=0.02              bigbinv=0.02              cigbinv=0.006
+ eigbinv=1.1               nigbinv=1                 aigc=0.009898
+ bigc=0.001383             cigc=1.515e-005           aigsd=0.0086
+ bigsd=0.0004353           cigsd=3.925e-020          nigc=1
+ poxedge=1                 pigcd=1.672               ntox=1
+ xrcrg1=12                 xrcrg2=1                  cgso=cgson_hv18_snw
+ cgdo=cgdon_hv18_snw       cgbo=0                    cgdl=cgdln_hv18_snw
+ cgsl=cgsln_hv18_snw       clc=1e-007                cle=0.6
+ cf=cfn_hv18_snw           ckappas=0.6               ckappad=0.6
+ acde=0.3                  moin=5.2                  noff=2.9337
+ voffcv=-0.16925           tvoff=0.001               ltvoff=0
+ wtvoff=0                  ptvoff=0                  kt1=-0.087747556+dkt1n_hv18_snw
+ lkt1=-5.3840427e-008+dlkt1n_hv18_snw                wkt1=-1.9734444e-007+dwkt1n_hv18_snw
+ pkt1=6.3146667e-014+dpkt1n_hv18_snw                 kt1l=0
+ kt2=-0.079371532          lkt2=1.2087851e-008       wkt2=2.3168533e-007
+ pkt2=-7.7188907e-014      ute=-1.35                 ua1=-1.8651244e-009
+ lua1=1.4458745e-015       wua1=1.0296244e-014       pua1=-3.6014649e-021
+ ub1=4.3317773e-019        lub1=-7.7933508e-025      wub1=-1.1837977e-023
+ pub1=4.0708548e-030       uc1=9.3584356e-010        luc1=-2.7995812e-016
+ wuc1=-1.7736276e-015      puc1=5.843882e-022        prt=0
+ at=-200000+datn_hv18_snw  jss=5.23e-007             jsws=2.52e-013
+ jswgs=2.52e-013           njs=1.02                  njd=1.02
+ ijthsfwd=0.01             ijthdfwd=0.01             ijthsrev=0.01
+ ijthdrev=0.01             bvs=8.4                   xjbvs=1
+ xjbvd=1                   jsd=1.03e-006             jswd=1.14e-012
+ jswgd=1.14e-012           bvd=14.1                  jtsswgs=3e-009+djtsswgsn_hv18_snw
+ jtsswgd=6e-008+djtsswgdn_hv18_snw                   njtsswg=20+dnjtsswgn_hv18_snw
+ xtsswgs=0.1               xtsswgd=0.75              tnjtsswg=0.5
+ vtsswgs=0.7               vtsswgd=0.05              pbs=0.5
+ cjs=cjsn_hv18_snw         mjs=0.24                  pbsws=0.3
+ cjsws=cjswsn_hv18_snw     mjsws=0.013               pbswgs=0.5
+ cjswgs=cjswgsn_hv18_snw   mjswgs=0.3                pbd=0.56
+ cjd=cjdn_hv18_snw         mjd=0.36                  pbswd=0.8
+ cjswd=cjswdn_hv18_snw     mjswd=0.31                pbswgd=0.8
+ cjswgd=cjswgdn_hv18_snw   mjswgd=0.36               tpb=0.002
+ tcj=0.0018                tpbsw=0.0025              tcjsw=0.0011
+ tpbswg=0.0028             tcjswg=0.00157            xtis=3
+ xtid=3                    dmcg=6.4e-08              dmci=6.4e-08
+ dmdg=0                    dmcgt=0                   dwj=0
+ xgw=0                     xgl=-1.09e-08             rshg=15.6
+ gbmin=1e-012              rbpb=50                   rbpd=50
+ rbps=50                   rbdb=50                   rbsb=50
+ ngcon=1                   wnfactor=0+dwnfactorn_hv18_snw
+ lnfactor=0+dlnfactorn_hv18_snw                      pnfactor=0+dpnfactorn_hv18_snw
+ weta0=0+dweta0n_hv18_snw  lat=0+dlatn_hv18_snw      wat=0+dwatn_hv18_snw
+ pat=0+dpatn_hv18_snw      lagidl=0+dlagidln_hv18_snw
+ pagidl=0+dpagidln_hv18_snw                          lbgidl=0+dlbgidln_hv18_snw
+ wbgidl=0+dwbgidln_hv18_snw                          pbgidl=0+dpbgidln_hv18_snw
+ minr=1e-3

     16: type=n
+ lmin=1e-005-dxln_hv18_snw lmax=900.001e-06          wmin=0.6e-06
+ wmax=1e-006-dxwn_hv18_snw version=4.5               binunit=2
+ paramchk=1                mobmod=0                  capmod=2
+ igcmod=0                  igbmod=0                  diomod=1
+ rdsmod=1                  rbodymod=0                rgeomod=1
+ rgatemod=1*rgflag_hv18_snw_spw                      permod=1
+ acnqsmod=0                trnqsmod=0                tempmod=0
+ tnom=25                   toxe=toxn_hv18_snw        toxm=3.58e-009
+ dtox=2.7936e-010          epsrox=3.9                wint=0
+ lint=2.45e-007            ll=0                      wl=0
+ lln=1                     wln=1                     lw=0
+ ww=0                      lwn=1                     wwn=1
+ lwl=0                     wwl=0                     llc=0
+ wlc=0                     lwc=0                     wwc=0
+ lwlc=0                    wwlc=0                    xl=1e-08+dxln_hv18_snw
+ xw=0+dxwn_hv18_snw        dlc=ddlcn_hv18_snw        dwc=0
+ xpart=1                   toxref=3e-009             dlcig=2.5e-009
+ vth0=0.57387499+dvthn_hv18_snw                      wvth0=-1.5105e-008+dwvthn_hv18_snw
+ k1=0.24874                k2=0.063+dk2n_hv18_snw    wk2=5.1e-011+dwk2n_hv18_snw
+ k3=-1.82                  k3b=1.0692                w0=0
+ dvt0=1.1319               dvt1=0.0055               dvt2=0.00050391
+ dvt0w=0                   dvt1w=0                   dvt2w=0
+ dsub=0.25                 minv=-0.4444              voffl=-5e-009
+ dvtp0=2.1516e-007         dvtp1=0.01                lpe0=5e-007
+ lpeb=2.4075e-007          xj=6.7e-008               ngate=8.5997e+020
+ ndep=9e+017               nsd=1e+020                phin=0.185
+ cdsc=0                    cdscb=0                   cdscd=0
+ cit=-6.2510135e-005+dcitn_hv18_snw                  wcit=2.021699e-010+dwcitn_hv18_snw
+ voff=-0.17927503+dvoffn_hv18_snw                    wvoff=6.315015e-009+dwvoffn_hv18_snw
+ nfactor=0.6+dnfactorn_hv18_snw                      eta0=0.0010241+deta0n_hv18_snw
+ etab=-0.062137454         wetab=1.4089182e-008      ud=0
+ lud=0                     wud=0                     pud=0
+ u0=0.032804+du0n_hv18_snw wu0=-1.2690015e-009+dwu0n_hv18_snw
+ ua=-7.9716013e-010        wua=1.2900075e-017        ub=2.1327e-018
+ wub=-1.584e-025           uc=1.0404509e-010         wuc=-1.1469054e-017
+ vsat=160000+dvsatn_hv18_snw                         a0=2.3283014+da0n_hv18_snw
+ wa0=-1.859997e-007+dwa0n_hv18_snw                   ags=0.65755003+dagsn_hv18_snw
+ wags=-3.2430015e-008+dwagsn_hv18_snw                a1=0
+ a2=1                      b0=0                      b1=0
+ keta=-0.0575535           wketa=4.2105e-009         dwg=0
+ dwb=0                     pclm=0.014996             pdiblc1=0
+ pdiblc2=0.00010000005     wpdiblc2=-4.65e-017       pdiblcb=0
+ drout=0.56                pvag=0.45                 delta=0.01
+ pscbe1=9.264e+008         pscbe2=1e-020             fprout=100
+ pdits=0                   pditsd=0                  pditsl=0
+ rsh=17.5                  rsw=65.35                 rdw=600
+ prwg=0                    prwb=0                    wr=1
+ alpha0=6.3669e-08         alpha1=1.5                beta0=29.5
+ agidl=1e-008+dagidln_hv18_snw                       bgidl=8e+009+dbgidln_hv18_snw
+ cgidl=21.599              egidl=0.55661             aigbacc=0.01238
+ bigbacc=0.006109          cigbacc=0.2809            nigbacc=4.05
+ aigbinv=0.02              bigbinv=0.02              cigbinv=0.006
+ eigbinv=1.1               nigbinv=1                 aigc=0.009898
+ bigc=0.001383             cigc=1.515e-005           aigsd=0.0086
+ bigsd=0.0004353           cigsd=3.925e-020          nigc=1
+ poxedge=1                 pigcd=1.672               ntox=1
+ xrcrg1=12                 xrcrg2=1                  cgso=cgson_hv18_snw
+ cgdo=cgdon_hv18_snw       cgbo=0                    cgdl=cgdln_hv18_snw
+ cgsl=cgsln_hv18_snw       clc=1e-007                cle=0.6
+ cf=cfn_hv18_snw           ckappas=0.6               ckappad=0.6
+ acde=0.3                  moin=5.2                  noff=2.9337
+ voffcv=-0.16925           tvoff=0.001               ltvoff=0
+ wtvoff=0                  ptvoff=0                  kt1=-0.19019+dkt1n_hv18_snw
+ wkt1=-8.67e-009+dwkt1n_hv18_snw                     kt1l=0
+ kt2=-0.0706675            wkt2=-2.39775e-008        ute=-1.35
+ ua1=9.4532502e-010        wua1=-2.3149501e-016      ub1=-1.106005e-018
+ wub1=3.55695e-025         uc1=2.09595e-010          wuc1=7.0995e-017
+ prt=0                     at=8.0897786e-005+datn_hv18_snw
+ wat=-1.9690445e-011+dwatn_hv18_snw                  jss=5.23e-007
+ jsws=2.52e-013            jswgs=2.52e-013           njs=1.02
+ njd=1.02                  ijthsfwd=0.01             ijthdfwd=0.01
+ ijthsrev=0.01             ijthdrev=0.01             bvs=8.4
+ xjbvs=1                   xjbvd=1                   jsd=1.03e-006
+ jswd=1.14e-012            jswgd=1.14e-012           bvd=14.1
+ jtsswgs=3e-009+djtsswgsn_hv18_snw                   jtsswgd=6e-008+djtsswgdn_hv18_snw
+ njtsswg=20+dnjtsswgn_hv18_snw                       xtsswgs=0.1
+ xtsswgd=0.75              tnjtsswg=0.5              vtsswgs=0.7
+ vtsswgd=0.05              pbs=0.5                   cjs=cjsn_hv18_snw
+ mjs=0.24                  pbsws=0.3                 cjsws=cjswsn_hv18_snw
+ mjsws=0.013               pbswgs=0.5                cjswgs=cjswgsn_hv18_snw
+ mjswgs=0.3                pbd=0.56                  cjd=cjdn_hv18_snw
+ mjd=0.36                  pbswd=0.8                 cjswd=cjswdn_hv18_snw
+ mjswd=0.31                pbswgd=0.8                cjswgd=cjswgdn_hv18_snw
+ mjswgd=0.36               tpb=0.002                 tcj=0.0018
+ tpbsw=0.0025              tcjsw=0.0011              tpbswg=0.0028
+ tcjswg=0.00157            xtis=3                    xtid=3
+ dmcg=6.4e-08              dmci=6.4e-08              dmdg=0
+ dmcgt=0                   dwj=0                     xgw=0
+ xgl=-1.09e-08             rshg=15.6                 gbmin=1e-012
+ rbpb=50                   rbpd=50                   rbps=50
+ rbdb=50                   rbsb=50                   ngcon=1
+ lvth0=0+dlvthn_hv18_snw   pvth0=0+dpvthn_hv18_snw   lu0=0+dlu0n_hv18_snw
+ pu0=0+dpu0n_hv18_snw      la0=0+dla0n_hv18_snw      pa0=0+dpa0n_hv18_snw
+ lags=0+dlagsn_hv18_snw    pags=0+dpagsn_hv18_snw    lvsat=0+dlvsatn_hv18_snw
+ wnfactor=0+dwnfactorn_hv18_snw                      lnfactor=0+dlnfactorn_hv18_snw
+ pnfactor=0+dpnfactorn_hv18_snw                      pvsat=0+dpvsatn_hv18_snw
+ wvsat=0+dwvsatn_hv18_snw  lk2=0+dlk2n_hv18_snw      pk2=0+dpk2n_hv18_snw
+ weta0=0+dweta0n_hv18_snw  lcit=0+dlcitn_hv18_snw    pcit=0+dpcitn_hv18_snw
+ lvoff=0+dlvoffn_hv18_snw  pvoff=0+dpvoffn_hv18_snw  lkt1=0+dlkt1n_hv18_snw
+ pkt1=0+dpkt1n_hv18_snw    lat=0+dlatn_hv18_snw      pat=0+dpatn_hv18_snw
+ lagidl=0+dlagidln_hv18_snw                          wagidl=0+dwagidln_hv18_snw
+ pagidl=0+dpagidln_hv18_snw                          lbgidl=0+dlbgidln_hv18_snw
+ wbgidl=0+dwbgidln_hv18_snw                          pbgidl=0+dpbgidln_hv18_snw
+ minr=1e-3

     17: type=n
+ lmin=1e-006-dxln_hv18_snw lmax=1e-005-dxln_hv18_snw wmin=0.6e-06
+ wmax=1e-006-dxwn_hv18_snw version=4.5               binunit=2
+ paramchk=1                mobmod=0                  capmod=2
+ igcmod=0                  igbmod=0                  diomod=1
+ rdsmod=1                  rbodymod=0                rgeomod=1
+ rgatemod=1*rgflag_hv18_snw_spw                      permod=1
+ acnqsmod=0                trnqsmod=0                tempmod=0
+ tnom=25                   toxe=toxn_hv18_snw        toxm=3.58e-009
+ dtox=2.7936e-010          epsrox=3.9                wint=0
+ lint=2.45e-007            ll=0                      wl=0
+ lln=1                     wln=1                     lw=0
+ ww=0                      lwn=1                     wwn=1
+ lwl=0                     wwl=0                     llc=0
+ wlc=0                     lwc=0                     wwc=0
+ lwlc=0                    wwlc=0                    xl=1e-08+dxln_hv18_snw
+ xw=0+dxwn_hv18_snw        dlc=ddlcn_hv18_snw        dwc=0
+ xpart=1                   toxref=3e-009             dlcig=2.5e-009
+ vth0=0.57304069+dvthn_hv18_snw                      lvth0=7.942615e-009+dlvthn_hv18_snw
+ wvth0=-1.5449931e-008+dwvthn_hv18_snw               pvth0=3.2837798e-015+dpvthn_hv18_snw
+ k1=0.24874                k2=0.063286719+dk2n_hv18_snw
+ lk2=-2.7295939e-009+dlk2n_hv18_snw                  wk2=-3.0926933e-010+dwk2n_hv18_snw
+ pk2=3.4298e-015+dpk2n_hv18_snw                      k3=-1.82
+ k3b=1.0692                w0=0                      dvt0=1.1319
+ dvt1=0.0055               dvt2=0.00050391           dvt0w=0
+ dvt1w=0                   dvt2w=0                   dsub=0.25
+ minv=-0.44437689          lminv=-2.2001764e-010     wminv=-6.9332563e-011
+ pminv=6.6005293e-016      voffl=-5e-009             dvtp0=2.1516e-007
+ dvtp1=0.01                lpe0=5e-007               lpeb=2.4075e-007
+ xj=6.7e-008               ngate=8.5997e+020         ndep=9e+017
+ nsd=1e+020                phin=0.185                cdsc=0
+ cdscb=0                   cdscd=0                   cit=-7.7431669e-005+dcitn_hv18_snw
+ lcit=1.4205449e-010+dlcitn_hv18_snw                 wcit=1.9303186e-010+dwcitn_hv18_snw
+ pcit=8.6995018e-017+dpcitn_hv18_snw                 voff=-0.18172941+dvoffn_hv18_snw
+ lvoff=2.3365893e-008+dlvoffn_hv18_snw               wvoff=6.994475e-009+dwvoffn_hv18_snw
+ pvoff=-6.468527e-015+dpvoffn_hv18_snw               nfactor=0.6+dnfactorn_hv18_snw
+ eta0=0.0010241+deta0n_hv18_snw                      etab=-0.062137454
+ wetab=1.4089182e-008      ud=0                      lud=0
+ wud=0                     pud=0                     u0=0.032183271+du0n_hv18_snw
+ lu0=5.9093992e-009+dlu0n_hv18_snw                   wu0=-1.3439674e-009+dwu0n_hv18_snw
+ pu0=7.1368306e-016+dpu0n_hv18_snw                   ua=-8.4578567e-010
+ lua=4.6291994e-016        wua=2.8192243e-017        pua=-1.4558297e-022
+ ub=2.1417999e-018         lub=-8.6631947e-026       wub=-1.7573314e-025
+ pub=1.6501323e-031        uc=1.011571e-010          luc=2.7493894e-017
+ wuc=-1.2109171e-017       puc=6.0939767e-024        vsat=158988.9+dvsatn_hv18_snw
+ lvsat=0.0096257719+dlvsatn_hv18_snw                 wvsat=0.00043332852+dwvsatn_hv18_snw
+ pvsat=-4.1253308e-009+dpvsatn_hv18_snw              a0=2.5025842+da0n_hv18_snw-0.0361111*ff_flag_hv18_snw_spw+0.0361111*ss_flag_hv18_snw_spw
+ la0=-1.6591894e-006+dla0n_hv18_snw+3.43778e-07*ff_flag_hv18_snw_spw-3.43778e-07*ss_flag_hv18_snw_spw
+ wa0=-1.8905984e-007+dwa0n_hv18_snw+4.33337e-09*ff_flag_hv18_snw_spw-4.33337e-09*ss_flag_hv18_snw_spw
+ pa0=2.9132814e-014+dpa0n_hv18_snw-4.12537e-14*ff_flag_hv18_snw_spw+4.12537e-14*ss_flag_hv18_snw_spw
+ ags=0.68375542+dagsn_hv18_snw+0.0173333*ff_flag_hv18_snw_spw-0.0173333*ss_flag_hv18_snw_spw
+ lags=-2.4947798e-007+dlagsn_hv18_snw-1.65013e-07*ff_flag_hv18_snw_spw+1.65013e-07*ss_flag_hv18_snw_spw
+ wags=-3.2410947e-008+dwagsn_hv18_snw+0.0*ff_flag_hv18_snw_spw+0.0*ss_flag_hv18_snw_spw
+ pags=-1.8153106e-016+dpagsn_hv18_snw+0.0*ff_flag_hv18_snw_spw+0.0*ss_flag_hv18_snw_spw
+ a1=0                      a2=1                      b0=0
+ b1=0                      keta=-0.056131807         lketa=-1.3534662e-008
+ wketa=5.1186698e-009      pketa=-8.6458675e-015     dwg=0
+ dwb=0                     pclm=0.014996             pdiblc1=0
+ pdiblc2=0.00010433333     lpdiblc2=-4.1253334e-011  wpdiblc2=-4.3333344e-012
+ ppdiblc2=4.1253334e-017   pdiblcb=0                 drout=0.56
+ pvag=0.45                 delta=0.01                pscbe1=9.264e+008
+ pscbe2=1e-020             fprout=100                pdits=0
+ pditsd=0                  pditsl=0                  rsh=17.5
+ rsw=65.35                 rdw=600                   prwg=0
+ prwb=0                    wr=1                      alpha0=6.3669e-08
+ alpha1=1.5                beta0=29.5                agidl=1e-008+dagidln_hv18_snw
+ bgidl=8e+009+dbgidln_hv18_snw                       cgidl=21.599
+ egidl=0.55661             aigbacc=0.01238           bigbacc=0.006109
+ cigbacc=0.2809            nigbacc=4.05              aigbinv=0.02
+ bigbinv=0.02              cigbinv=0.006             eigbinv=1.1
+ nigbinv=1                 aigc=0.009898             bigc=0.001383
+ cigc=1.515e-005           aigsd=0.0086              bigsd=0.0004353
+ cigsd=3.925e-020          nigc=1                    poxedge=1
+ pigcd=1.672               ntox=1                    xrcrg1=12
+ xrcrg2=1                  cgso=cgson_hv18_snw       cgdo=cgdon_hv18_snw
+ cgbo=0                    cgdl=cgdln_hv18_snw       cgsl=cgsln_hv18_snw
+ clc=1e-007                cle=0.6                   cf=cfn_hv18_snw
+ ckappas=0.6               ckappad=0.6               acde=0.3
+ moin=5.2                  noff=2.9337               voffcv=-0.16925
+ tvoff=0.001               ltvoff=0                  wtvoff=0
+ ptvoff=0                  kt1=-0.18867624+dkt1n_hv18_snw
+ lkt1=-1.4411156e-008+dlkt1n_hv18_snw                wkt1=-7.7964097e-009+dwkt1n_hv18_snw
+ pkt1=-8.316667e-015+dpkt1n_hv18_snw                 kt1l=0
+ kt2=-0.072845265          lkt2=2.0732539e-008       wkt2=-2.3280448e-008
+ pkt2=-6.636008e-015       ute=-1.35                 ua1=9.5296461e-010
+ lua1=-7.2729596e-017      wua1=-2.7561913e-016      pua1=4.2006595e-022
+ ub1=-1.1300839e-018       lub1=2.2923377e-025       wub1=3.9424651e-025
+ pub1=-3.6701427e-031      uc1=2.2530114e-010        luc1=-1.49524e-016
+ wuc1=6.158657e-017        puc1=8.9569191e-023       prt=0
+ at=7222.1421+datn_hv18_snw                          lat=-0.068755514+dlatn_hv18_snw
+ wat=0.0043332852+dwatn_hv18_snw                     pat=-4.1253308e-008+dpatn_hv18_snw
+ jss=5.23e-007             jsws=2.52e-013            jswgs=2.52e-013
+ njs=1.02                  njd=1.02                  ijthsfwd=0.01
+ ijthdfwd=0.01             ijthsrev=0.01             ijthdrev=0.01
+ bvs=8.4                   xjbvs=1                   xjbvd=1
+ jsd=1.03e-006             jswd=1.14e-012            jswgd=1.14e-012
+ bvd=14.1                  jtsswgs=3e-009+djtsswgsn_hv18_snw
+ jtsswgd=6e-008+djtsswgdn_hv18_snw                   njtsswg=20+dnjtsswgn_hv18_snw
+ xtsswgs=0.1               xtsswgd=0.75              tnjtsswg=0.5
+ vtsswgs=0.7               vtsswgd=0.05              pbs=0.5
+ cjs=cjsn_hv18_snw         mjs=0.24                  pbsws=0.3
+ cjsws=cjswsn_hv18_snw     mjsws=0.013               pbswgs=0.5
+ cjswgs=cjswgsn_hv18_snw   mjswgs=0.3                pbd=0.56
+ cjd=cjdn_hv18_snw         mjd=0.36                  pbswd=0.8
+ cjswd=cjswdn_hv18_snw     mjswd=0.31                pbswgd=0.8
+ cjswgd=cjswgdn_hv18_snw   mjswgd=0.36               tpb=0.002
+ tcj=0.0018                tpbsw=0.0025              tcjsw=0.0011
+ tpbswg=0.0028             tcjswg=0.00157            xtis=3
+ xtid=3                    dmcg=6.4e-08              dmci=6.4e-08
+ dmdg=0                    dmcgt=0                   dwj=0
+ xgw=0                     xgl=-1.09e-08             rshg=15.6
+ gbmin=1e-012              rbpb=50                   rbpd=50
+ rbps=50                   rbdb=50                   rbsb=50
+ ngcon=1                   wnfactor=0+dwnfactorn_hv18_snw
+ lnfactor=0+dlnfactorn_hv18_snw                      pnfactor=0+dpnfactorn_hv18_snw
+ weta0=0+dweta0n_hv18_snw  lagidl=0+dlagidln_hv18_snw
+ wagidl=0+dwagidln_hv18_snw                          pagidl=0+dpagidln_hv18_snw
+ lbgidl=0+dlbgidln_hv18_snw                          wbgidl=0+dwbgidln_hv18_snw
+ pbgidl=0+dpbgidln_hv18_snw                          minr=1e-3

     18: type=n
+ lmin=9e-007-dxln_hv18_snw lmax=1e-006-dxln_hv18_snw wmin=0.6e-06
+ wmax=1e-006-dxwn_hv18_snw version=4.5               binunit=2
+ paramchk=1                mobmod=0                  capmod=2
+ igcmod=0                  igbmod=0                  diomod=1
+ rdsmod=1                  rbodymod=0                rgeomod=1
+ rgatemod=1*rgflag_hv18_snw_spw                      permod=1
+ acnqsmod=0                trnqsmod=0                tempmod=0
+ tnom=25                   toxe=toxn_hv18_snw        toxm=3.58e-009
+ dtox=2.7936e-010          epsrox=3.9                wint=0
+ lint=2.45e-007            ll=0                      wl=0
+ lln=1                     wln=1                     lw=0
+ ww=0                      lwn=1                     wwn=1
+ lwl=0                     wwl=0                     llc=0
+ wlc=0                     lwc=0                     wwc=0
+ lwlc=0                    wwlc=0                    xl=1e-08+dxln_hv18_snw
+ xw=0+dxwn_hv18_snw        dlc=ddlcn_hv18_snw        dwc=0
+ xpart=1                   toxref=3e-009             dlcig=2.5e-009
+ vth0=0.50960674+dvthn_hv18_snw                      lvth0=4.0928269e-008+dlvthn_hv18_snw
+ wvth0=-6.866844e-009+dwvthn_hv18_snw                pvth0=-1.1794255e-015+dpvthn_hv18_snw
+ k1=0.24874                k2=0.0477475+dk2n_hv18_snw
+ lk2=5.3508e-009+dlk2n_hv18_snw                      wk2=6.2361e-009+dwk2n_hv18_snw
+ pk2=2.6208e-017+dpk2n_hv18_snw                      k3=-1.82
+ k3b=1.0692                w0=0                      dvt0=1.1319
+ dvt1=0.0055               dvt2=0.00050391           dvt0w=0
+ dvt1w=0                   dvt2w=0                   dsub=0.25
+ minv=-0.44984             lminv=2.6208e-009         wminv=6.24e-009
+ pminv=-2.6208e-015        voffl=-5e-009             dvtp0=2.1516e-007
+ dvtp1=0.01                lpe0=5e-007               lpeb=2.4075e-007
+ xj=6.7e-008               ngate=8.5997e+020         ndep=9e+017
+ nsd=1e+020                phin=0.185                cdsc=0
+ cdscb=0                   cdscd=0                   cit=0.00040155007+dcitn_hv18_snw
+ lcit=-1.0701601e-010+dlcitn_hv18_snw                wcit=3.6146416e-010+dwcitn_hv18_snw
+ pcit=-5.8977828e-019+dpcitn_hv18_snw                voff=-0.112246+dvoffn_hv18_snw
+ lvoff=-1.276548e-008+dlvoffn_hv18_snw               wvoff=-3.1842e-008+dwvoffn_hv18_snw
+ pvoff=1.372644e-014+dpvoffn_hv18_snw                nfactor=0.6+dnfactorn_hv18_snw
+ eta0=0.0010241+deta0n_hv18_snw                      etab=-0.062137454
+ wetab=1.4089182e-008      ud=0                      lud=0
+ wud=0                     pud=0                     u0=0.0413215+du0n_hv18_snw
+ lu0=1.15752e-009+dlu0n_hv18_snw                     wu0=1.8429e-009+dwu0n_hv18_snw
+ pu0=-9.43488e-016+dpu0n_hv18_snw                    ua=3.437898e-009
+ lua=-1.7645955e-015       wua=-2.194632e-015        pua=1.0102856e-021
+ ub=-2.55828e-018          lub=2.3574096e-024        wub=2.69688e-024
+ pub=-1.3287456e-030       uc=-1.4152413e-010        luc=1.5368814e-016
+ wuc=1.8583808e-016        puc=-9.6838593e-023       vsat=251000+dvsatn_hv18_snw
+ lvsat=-0.03822+dlvsatn_hv18_snw                     wvsat=-0.039+dwvsatn_hv18_snw
+ pvsat=1.638e-008+dpvsatn_hv18_snw                   a0=1.8391243+da0n_hv18_snw+2.83*ff_flag_hv18_snw_spw-2.62*ss_flag_hv18_snw_spw
+ la0=-1.3141903e-006+dla0n_hv18_snw-1.1466e-06*ff_flag_hv18_snw_spw+1.0374e-06*ss_flag_hv18_snw_spw
+ wa0=-1.7266364e-007+dwa0n_hv18_snw-1.65e-06*ff_flag_hv18_snw_spw+3.9e-07*ss_flag_hv18_snw_spw
+ pa0=2.0606794e-014+dpa0n_hv18_snw+8.19e-13*ff_flag_hv18_snw_spw-1.638e-13*ss_flag_hv18_snw_spw
+ ags=-0.46269708+dagsn_hv18_snw-1.56*ff_flag_hv18_snw_spw+1.56*ss_flag_hv18_snw_spw
+ lags=3.4667732e-007+dlagsn_hv18_snw+6.552e-07*ff_flag_hv18_snw_spw-6.552e-07*ss_flag_hv18_snw_spw
+ wags=-6.0410698e-007+dwagsn_hv18_snw+0.0*ff_flag_hv18_snw_spw+0.0*ss_flag_hv18_snw_spw
+ pags=2.9710041e-013+dpagsn_hv18_snw+0.0*ff_flag_hv18_snw_spw+0.0*ss_flag_hv18_snw_spw
+ a1=0                      a2=1                      b0=0
+ b1=0                      keta=-0.065341113         lketa=-8.7458225e-009
+ wketa=-4.3215892e-008     pketa=1.6488105e-014      dwg=0
+ dwb=0                     pclm=0.014996             pdiblc1=0
+ pdiblc2=2.5000305e-005    lpdiblc2=-1.5834e-016     wpdiblc2=7.4999817e-011
+ ppdiblc2=9.5003999e-023   pdiblcb=0                 drout=0.56
+ pvag=0.45                 delta=0.01                pscbe1=9.264e+008
+ pscbe2=1e-020             fprout=100                pdits=0
+ pditsd=0                  pditsl=0                  rsh=17.5
+ rsw=65.35                 rdw=600                   prwg=0
+ prwb=0                    wr=1                      alpha0=6.3669e-08
+ alpha1=1.5                beta0=29.5                agidl=1e-008+dagidln_hv18_snw
+ bgidl=8e+009+dbgidln_hv18_snw                       cgidl=21.599
+ egidl=0.55661             aigbacc=0.01238           bigbacc=0.006109
+ cigbacc=0.2809            nigbacc=4.05              aigbinv=0.02
+ bigbinv=0.02              cigbinv=0.006             eigbinv=1.1
+ nigbinv=1                 aigc=0.009898             bigc=0.001383
+ cigc=1.515e-005           aigsd=0.0086              bigsd=0.0004353
+ cigsd=3.925e-020          nigc=1                    poxedge=1
+ pigcd=1.672               ntox=1                    xrcrg1=12
+ xrcrg2=1                  cgso=cgson_hv18_snw       cgdo=cgdon_hv18_snw
+ cgbo=0                    cgdl=cgdln_hv18_snw       cgsl=cgsln_hv18_snw
+ clc=1e-007                cle=0.6                   cf=cfn_hv18_snw
+ ckappas=0.6               ckappad=0.6               acde=0.3
+ moin=5.2                  noff=2.9337               voffcv=-0.16925
+ tvoff=0.001               ltvoff=0                  wtvoff=0
+ ptvoff=0                  kt1=-0.023568+dkt1n_hv18_snw
+ lkt1=-1.0026744e-007+dlkt1n_hv18_snw                wkt1=-1.72722e-007+dwkt1n_hv18_snw
+ pkt1=7.744464e-014+dpkt1n_hv18_snw                  kt1l=0
+ kt2=-0.13423686           lkt2=5.2656171e-008       wkt2=-2.5306934e-008
+ pkt2=-5.5822352e-015      ute=-1.35                 ua1=-5.7977e-009
+ lua1=3.437616e-015        wua1=3.75402e-015         pua1=-1.6753464e-021
+ ub1=6.0641413e-018        lub1=-3.5117633e-024      wub1=-3.4836008e-024
+ pub1=1.6494663e-030       uc1=2.6974359e-010        luc1=-1.7263407e-016
+ wuc1=2.2137393e-016       puc1=6.4797642e-024       prt=0
+ at=-125000+datn_hv18_snw  wat=-0.075+dwatn_hv18_snw jss=5.23e-007
+ jsws=2.52e-013            jswgs=2.52e-013           njs=1.02
+ njd=1.02                  ijthsfwd=0.01             ijthdfwd=0.01
+ ijthsrev=0.01             ijthdrev=0.01             bvs=8.4
+ xjbvs=1                   xjbvd=1                   jsd=1.03e-006
+ jswd=1.14e-012            jswgd=1.14e-012           bvd=14.1
+ jtsswgs=3e-009+djtsswgsn_hv18_snw                   jtsswgd=6e-008+djtsswgdn_hv18_snw
+ njtsswg=20+dnjtsswgn_hv18_snw                       xtsswgs=0.1
+ xtsswgd=0.75              tnjtsswg=0.5              vtsswgs=0.7
+ vtsswgd=0.05              pbs=0.5                   cjs=cjsn_hv18_snw
+ mjs=0.24                  pbsws=0.3                 cjsws=cjswsn_hv18_snw
+ mjsws=0.013               pbswgs=0.5                cjswgs=cjswgsn_hv18_snw
+ mjswgs=0.3                pbd=0.56                  cjd=cjdn_hv18_snw
+ mjd=0.36                  pbswd=0.8                 cjswd=cjswdn_hv18_snw
+ mjswd=0.31                pbswgd=0.8                cjswgd=cjswgdn_hv18_snw
+ mjswgd=0.36               tpb=0.002                 tcj=0.0018
+ tpbsw=0.0025              tcjsw=0.0011              tpbswg=0.0028
+ tcjswg=0.00157            xtis=3                    xtid=3
+ dmcg=6.4e-08              dmci=6.4e-08              dmdg=0
+ dmcgt=0                   dwj=0                     xgw=0
+ xgl=-1.09e-08             rshg=15.6                 gbmin=1e-012
+ rbpb=50                   rbpd=50                   rbps=50
+ rbdb=50                   rbsb=50                   ngcon=1
+ wnfactor=0+dwnfactorn_hv18_snw                      lnfactor=0+dlnfactorn_hv18_snw
+ pnfactor=0+dpnfactorn_hv18_snw                      weta0=0+dweta0n_hv18_snw
+ lat=0+dlatn_hv18_snw      pat=0+dpatn_hv18_snw      lagidl=0+dlagidln_hv18_snw
+ wagidl=0+dwagidln_hv18_snw                          pagidl=0+dpagidln_hv18_snw
+ lbgidl=0+dlbgidln_hv18_snw                          wbgidl=0+dwbgidln_hv18_snw
+ pbgidl=0+dpbgidln_hv18_snw                          minr=1e-3

     19: type=n
+ lmin=8.5e-007-dxln_hv18_snw                         lmax=9e-007-dxln_hv18_snw
+ wmin=0.6e-06              wmax=1e-006-dxwn_hv18_snw version=4.5
+ binunit=2                 paramchk=1                mobmod=0
+ capmod=2                  igcmod=0                  igbmod=0
+ diomod=1                  rdsmod=1                  rbodymod=0
+ rgeomod=1                 rgatemod=1*rgflag_hv18_snw_spw
+ permod=1                  acnqsmod=0                trnqsmod=0
+ tempmod=0                 tnom=25                   toxe=toxn_hv18_snw
+ toxm=3.58e-009            dtox=2.7936e-010          epsrox=3.9
+ wint=0                    lint=2.45e-007            ll=0
+ wl=0                      lln=1                     wln=1
+ lw=0                      ww=0                      lwn=1
+ wwn=1                     lwl=0                     wwl=0
+ llc=0                     wlc=0                     lwc=0
+ wwc=0                     lwlc=0                    wwlc=0
+ xl=1e-08+dxln_hv18_snw    xw=0+dxwn_hv18_snw        dlc=ddlcn_hv18_snw
+ dwc=0                     xpart=1                   toxref=3e-009
+ dlcig=2.5e-009            vth0=0.592181+dvthn_hv18_snw
+ lvth0=6.24708e-009+dlvthn_hv18_snw                  wvth0=-3.4539e-008+dwvthn_hv18_snw
+ pvth0=1.044288e-014+dpvthn_hv18_snw                 k1=0.24874
+ k2=-0.0108226+dk2n_hv18_snw                         lk2=2.9950242e-008+dlk2n_hv18_snw
+ wk2=1.009482e-007+dwk2n_hv18_snw                    pk2=-3.9752874e-014+dpk2n_hv18_snw
+ k3=-1.82                  k3b=1.0692                w0=0
+ dvt0=1.1319               dvt1=0.0055               dvt2=0.00050391
+ dvt0w=0                   dvt1w=0                   dvt2w=0
+ dsub=0.25                 minv=-0.442712            lminv=-3.7296e-010
+ wminv=-8.88e-010          pminv=3.7296e-016         voffl=-5e-009
+ dvtp0=2.1516e-007         dvtp1=0.01                lpe0=5e-007
+ lpeb=2.4075e-007          xj=6.7e-008               ngate=8.5997e+020
+ ndep=9e+017               nsd=1e+020                phin=0.185
+ cdsc=0                    cdscb=0                   cdscd=0
+ cit=-0.0010081676+dcitn_hv18_snw                    lcit=4.8506542e-010+dlcitn_hv18_snw
+ wcit=3.3319737e-010+dwcitn_hv18_snw                 pcit=1.1282273e-017+dpcitn_hv18_snw
+ voff=-0.373927+dvoffn_hv18_snw                      lvoff=9.714054e-008+dlvoffn_hv18_snw
+ wvoff=1.51023e-007+dwvoffn_hv18_snw                 pvoff=-6.307686e-014+dpvoffn_hv18_snw
+ nfactor=0.6+dnfactorn_hv18_snw                      eta0=0.0010241+deta0n_hv18_snw
+ etab=-0.062137454         wetab=1.4089182e-008      ud=0
+ lud=0                     wud=0                     pud=0
+ u0=0.0469894+du0n_hv18_snw                          lu0=-1.222998e-009+dlu0n_hv18_snw
+ wu0=-3.4116e-009+dwu0n_hv18_snw                     pu0=1.263402e-015+dpu0n_hv18_snw
+ ua=-5.95244e-010          lua=-7.067592e-017        wua=7.4472e-016
+ pua=-2.242422e-022        ub=2.40932e-018           lub=2.710176e-025
+ wub=-1.04178e-024         pub=2.414916e-031         uc=1.786677e-010
+ luc=1.9207564e-017        wuc=1.5995422e-016        puc=-8.5967373e-023
+ vsat=160000+dvsatn_hv18_snw                         a0=0.80577689+da0n_hv18_snw-2.305*ff_flag_hv18_snw_spw-0.372*ss_flag_hv18_snw_spw
+ la0=-8.8018436e-007+dla0n_hv18_snw+1.0101e-06*ff_flag_hv18_snw_spw+9.324e-08*ss_flag_hv18_snw_spw
+ wa0=6.0900237e-007+dwa0n_hv18_snw+8.55e-07*ff_flag_hv18_snw_spw+0.0*ss_flag_hv18_snw_spw
+ pa0=-3.0769293e-013+dpa0n_hv18_snw-2.331e-13*ff_flag_hv18_snw_spw+0.0*ss_flag_hv18_snw_spw
+ ags=-1.2416682+dagsn_hv18_snw                       lags=6.7384517e-007+dlagsn_hv18_snw
+ wags=4.957705e-007+dwagsn_hv18_snw                  pags=-1.6484813e-013+dpagsn_hv18_snw
+ a1=0                      a2=1                      b0=0
+ b1=0                      keta=-0.048912956         lketa=-1.5645649e-008
+ wketa=-9.9729245e-008     pketa=4.0223713e-014      dwg=0
+ dwb=0                     pclm=0.014996             pdiblc1=0
+ pdiblc2=-0.0012700012     lpdiblc2=5.4390046e-010   wpdiblc2=6.300007e-010
+ ppdiblc2=-2.3310028e-016  pdiblcb=0                 drout=0.56
+ pvag=0.45                 delta=0.01                pscbe1=9.264e+008
+ pscbe2=1e-020             fprout=100                pdits=0
+ pditsd=0                  pditsl=0                  rsh=17.5
+ rsw=65.35                 rdw=600                   prwg=0
+ prwb=0                    wr=1                      alpha0=6.3669e-08
+ alpha1=1.5                beta0=29.5                agidl=1e-008+dagidln_hv18_snw
+ bgidl=8e+009+dbgidln_hv18_snw                       cgidl=21.599
+ egidl=0.55661             aigbacc=0.01238           bigbacc=0.006109
+ cigbacc=0.2809            nigbacc=4.05              aigbinv=0.02
+ bigbinv=0.02              cigbinv=0.006             eigbinv=1.1
+ nigbinv=1                 aigc=0.009898             bigc=0.001383
+ cigc=1.515e-005           aigsd=0.0086              bigsd=0.0004353
+ cigsd=3.925e-020          nigc=1                    poxedge=1
+ pigcd=1.672               ntox=1                    xrcrg1=12
+ xrcrg2=1                  cgso=cgson_hv18_snw       cgdo=cgdon_hv18_snw
+ cgbo=0                    cgdl=cgdln_hv18_snw       cgsl=cgsln_hv18_snw
+ clc=1e-007                cle=0.6                   cf=cfn_hv18_snw
+ ckappas=0.6               ckappad=0.6               acde=0.3
+ moin=5.2                  noff=2.9337               voffcv=-0.16925
+ tvoff=0.001               ltvoff=0                  wtvoff=0
+ ptvoff=0                  kt1=-0.230369+dkt1n_hv18_snw
+ lkt1=-1.341102e-008+dlkt1n_hv18_snw                 wkt1=4.8633e-008+dwkt1n_hv18_snw
+ pkt1=-1.552446e-014+dpkt1n_hv18_snw                 kt1l=0
+ kt2=-0.69326179           lkt2=2.8744664e-007       wkt2=4.6947162e-007
+ pkt2=-2.1338923e-013      ute=-1.35                 ua1=-1.9474426e-009
+ lua1=1.8205079e-015       wua1=7.4744556e-016       pua1=-4.1258513e-022
+ ub1=4.8253037e-018        lub1=-2.9914515e-024      wub1=-1.8295822e-024
+ pub1=9.5477853e-031       uc1=3.2543874e-009        luc1=-1.4261845e-015
+ wuc1=-2.3410862e-015      puc1=1.082713e-021        prt=0
+ at=430000+datn_hv18_snw   lat=-0.2331+dlatn_hv18_snw
+ wat=-0.63+dwatn_hv18_snw  pat=2.331e-007+dpatn_hv18_snw
+ jss=5.23e-007             jsws=2.52e-013            jswgs=2.52e-013
+ njs=1.02                  njd=1.02                  ijthsfwd=0.01
+ ijthdfwd=0.01             ijthsrev=0.01             ijthdrev=0.01
+ bvs=8.4                   xjbvs=1                   xjbvd=1
+ jsd=1.03e-006             jswd=1.14e-012            jswgd=1.14e-012
+ bvd=14.1                  jtsswgs=3e-009+djtsswgsn_hv18_snw
+ jtsswgd=6e-008+djtsswgdn_hv18_snw                   njtsswg=20+dnjtsswgn_hv18_snw
+ xtsswgs=0.1               xtsswgd=0.75              tnjtsswg=0.5
+ vtsswgs=0.7               vtsswgd=0.05              pbs=0.5
+ cjs=cjsn_hv18_snw         mjs=0.24                  pbsws=0.3
+ cjsws=cjswsn_hv18_snw     mjsws=0.013               pbswgs=0.5
+ cjswgs=cjswgsn_hv18_snw   mjswgs=0.3                pbd=0.56
+ cjd=cjdn_hv18_snw         mjd=0.36                  pbswd=0.8
+ cjswd=cjswdn_hv18_snw     mjswd=0.31                pbswgd=0.8
+ cjswgd=cjswgdn_hv18_snw   mjswgd=0.36               tpb=0.002
+ tcj=0.0018                tpbsw=0.0025              tcjsw=0.0011
+ tpbswg=0.0028             tcjswg=0.00157            xtis=3
+ xtid=3                    dmcg=6.4e-08              dmci=6.4e-08
+ dmdg=0                    dmcgt=0                   dwj=0
+ xgw=0                     xgl=-1.09e-08             rshg=15.6
+ gbmin=1e-012              rbpb=50                   rbpd=50
+ rbps=50                   rbdb=50                   rbsb=50
+ ngcon=1                   lvsat=0+dlvsatn_hv18_snw  wnfactor=0+dwnfactorn_hv18_snw
+ lnfactor=0+dlnfactorn_hv18_snw                      pnfactor=0+dpnfactorn_hv18_snw
+ pvsat=0+dpvsatn_hv18_snw  wvsat=0+dwvsatn_hv18_snw  weta0=0+dweta0n_hv18_snw
+ lagidl=0+dlagidln_hv18_snw                          wagidl=0+dwagidln_hv18_snw
+ pagidl=0+dpagidln_hv18_snw                          lbgidl=0+dlbgidln_hv18_snw
+ wbgidl=0+dwbgidln_hv18_snw                          pbgidl=0+dpbgidln_hv18_snw
+ minr=1e-3

     20: type=n
+ lmin=0.792e-06            lmax=8.5e-007-dxln_hv18_snw
+ wmin=0.6e-06              wmax=1e-006-dxwn_hv18_snw version=4.5
+ binunit=2                 paramchk=1                mobmod=0
+ capmod=2                  igcmod=0                  igbmod=0
+ diomod=1                  rdsmod=1                  rbodymod=0
+ rgeomod=1                 rgatemod=1*rgflag_hv18_snw_spw
+ permod=1                  acnqsmod=0                trnqsmod=0
+ tempmod=0                 tnom=25                   toxe=toxn_hv18_snw
+ toxm=3.58e-009            dtox=2.7936e-010          epsrox=3.9
+ wint=0                    lint=2.45e-007            ll=0
+ wl=0                      lln=1                     wln=1
+ lw=0                      ww=0                      lwn=1
+ wwn=1                     lwl=0                     wwl=0
+ llc=0                     wlc=0                     lwc=0
+ wwc=0                     lwlc=0                    wwlc=0
+ xl=1e-08+dxln_hv18_snw    xw=0+dxwn_hv18_snw        dlc=ddlcn_hv18_snw
+ dwc=0                     xpart=1                   toxref=3e-009
+ dlcig=2.5e-009            vth0=0.612745+dvthn_hv18_snw
+ lvth0=-1.3616e-009+dlvthn_hv18_snw                  wvth0=-4.7691e-008+dwvthn_hv18_snw
+ pvth0=1.530912e-014+dpvthn_hv18_snw                 k1=0.24874
+ k2=0.17971438+dk2n_hv18_snw                         lk2=-4.0548442e-008+dlk2n_hv18_snw
+ wk2=-6.686639e-008+dwk2n_hv18_snw                   pk2=2.2338524e-014+dpk2n_hv18_snw
+ k3=-1.82                  k3b=1.0692                w0=0
+ dvt0=1.1319               dvt1=0.0055               dvt2=0.00050391
+ dvt0w=0                   dvt1w=0                   dvt2w=0
+ dsub=0.25                 minv=-0.436808            lminv=-2.55744e-009
+ wminv=-6.792e-009         pminv=2.55744e-015        voffl=-5e-009
+ dvtp0=2.1516e-007         dvtp1=0.01                lpe0=5e-007
+ lpeb=2.4075e-007          xj=6.7e-008               ngate=8.5997e+020
+ ndep=9e+017               nsd=1e+020                phin=0.185
+ cdsc=0                    cdscb=0                   cdscd=0
+ cit=-0.000892892+dcitn_hv18_snw                     lcit=4.4241344e-010+dlcitn_hv18_snw
+ wcit=6.55146e-010+dwcitn_hv18_snw                   pcit=-1.0783872e-016+dpcitn_hv18_snw
+ voff=-0.043641+dvoffn_hv18_snw                      lvoff=-2.506528e-008+dlvoffn_hv18_snw
+ wvoff=-7.4271e-008+dwvoffn_hv18_snw                 pvoff=2.028192e-014+dpvoffn_hv18_snw
+ nfactor=0.6+dnfactorn_hv18_snw                      eta0=0.0010241+deta0n_hv18_snw
+ etab=-0.062137454         wetab=1.4089182e-008      ud=0
+ lud=0                     wud=0                     pud=0
+ u0=0.0423144+du0n_hv18_snw                          lu0=5.06752e-010+dlu0n_hv18_snw
+ wu0=7.326e-010+dwu0n_hv18_snw                       pu0=-2.69952e-016+dpu0n_hv18_snw
+ ua=-1.572692e-009         lua=2.9097984e-016        wua=6.90468e-016
+ pua=-2.0416896e-022       ub=3.61252e-018           lub=-1.741664e-025
+ wub=-5.5134e-025          pub=6.00288e-032          uc=6.0032082e-010
+ luc=-1.3680409e-016       wuc=-1.2411481e-016       puc=1.9138169e-023
+ vsat=160000+dvsatn_hv18_snw                         a0=3.3081803+da0n_hv18_snw+3.145*ff_flag_hv18_snw_spw-0.888*ss_flag_hv18_snw_spw
+ la0=-1.8060736e-006+dla0n_hv18_snw-1.0064e-06*ff_flag_hv18_snw_spw+2.8416e-07*ss_flag_hv18_snw_spw
+ wa0=-7.0644015e-007+dwa0n_hv18_snw+1.665e-06*ff_flag_hv18_snw_spw+0.0*ss_flag_hv18_snw_spw
+ pa0=1.790208e-013+dpa0n_hv18_snw-5.328e-13*ff_flag_hv18_snw_spw+0.0*ss_flag_hv18_snw_spw
+ ags=-0.590289+dagsn_hv18_snw                        lags=4.3283488e-007+dlagsn_hv18_snw
+ wags=-2.89509e-007+dwagsn_hv18_snw                  pags=1.2570528e-013+dpagsn_hv18_snw
+ a1=0                      a2=1                      b0=0
+ b1=0                      keta=-0.2656881           lketa=6.4561156e-008
+ wketa=-3.3160498e-008     pketa=1.5593276e-014      dwg=0
+ dwb=0                     pclm=0.0149704            lpclm=9.472e-012
+ pdiblc1=0                 pdiblc2=-0.00044000025    lpdiblc2=2.3680012e-010
+ wpdiblc2=1.4699999e-016   ppdiblc2=-7.1039997e-023  pdiblcb=0
+ drout=0.56                pvag=0.45                 delta=0.01
+ pscbe1=9.264e+008         pscbe2=1e-020             fprout=100
+ pdits=0                   pditsd=0                  pditsl=0
+ rsh=17.5                  rsw=65.35                 rdw=600
+ prwg=0                    prwb=0                    wr=1
+ alpha0=6.3669e-08         alpha1=1.5                beta0=29.5
+ agidl=1e-008+dagidln_hv18_snw                       bgidl=8e+009+dbgidln_hv18_snw
+ cgidl=21.599              egidl=0.55661             aigbacc=0.01238
+ bigbacc=0.006109          cigbacc=0.2809            nigbacc=4.05
+ aigbinv=0.02              bigbinv=0.02              cigbinv=0.006
+ eigbinv=1.1               nigbinv=1                 aigc=0.009898
+ bigc=0.001383             cigc=1.515e-005           aigsd=0.0086
+ bigsd=0.0004353           cigsd=3.925e-020          nigc=1
+ poxedge=1                 pigcd=1.672               ntox=1
+ xrcrg1=12                 xrcrg2=1                  cgso=cgson_hv18_snw
+ cgdo=cgdon_hv18_snw       cgbo=0                    cgdl=cgdln_hv18_snw
+ cgsl=cgsln_hv18_snw       clc=1e-007                cle=0.6
+ cf=cfn_hv18_snw           ckappas=0.6               ckappad=0.6
+ acde=0.3                  moin=5.2                  noff=2.9337
+ voffcv=-0.16925           tvoff=0.001               ltvoff=0
+ wtvoff=0                  ptvoff=0                  kt1=-0.326039+dkt1n_hv18_snw
+ lkt1=2.198688e-008+dlkt1n_hv18_snw                  wkt1=4.0947e-008+dwkt1n_hv18_snw
+ pkt1=-1.268064e-014+dpkt1n_hv18_snw                 kt1l=0
+ kt2=0.70589299            lkt2=-2.3024063e-007      wkt2=-5.5357919e-007
+ pkt2=1.6513957e-013       ute=-1.35                 ua1=1.7273649e-008
+ lua1=-5.291296e-015       wua1=-8.8425294e-015      pua1=3.1357056e-021
+ ub1=-2.5442099e-017       lub1=8.2074874e-024       wub1=1.4037299e-023
+ pub1=-4.9159676e-030      uc1=-4.5646451e-009       luc1=1.4668576e-015
+ wuc1=3.7268611e-015       puc1=-1.1624275e-021      prt=0
+ at=-200000+datn_hv18_snw  jss=5.23e-007             jsws=2.52e-013
+ jswgs=2.52e-013           njs=1.02                  njd=1.02
+ ijthsfwd=0.01             ijthdfwd=0.01             ijthsrev=0.01
+ ijthdrev=0.01             bvs=8.4                   xjbvs=1
+ xjbvd=1                   jsd=1.03e-006             jswd=1.14e-012
+ jswgd=1.14e-012           bvd=14.1                  jtsswgs=3e-009+djtsswgsn_hv18_snw
+ jtsswgd=6e-008+djtsswgdn_hv18_snw                   njtsswg=20+dnjtsswgn_hv18_snw
+ xtsswgs=0.1               xtsswgd=0.75              tnjtsswg=0.5
+ vtsswgs=0.7               vtsswgd=0.05              pbs=0.5
+ cjs=cjsn_hv18_snw         mjs=0.24                  pbsws=0.3
+ cjsws=cjswsn_hv18_snw     mjsws=0.013               pbswgs=0.5
+ cjswgs=cjswgsn_hv18_snw   mjswgs=0.3                pbd=0.56
+ cjd=cjdn_hv18_snw         mjd=0.36                  pbswd=0.8
+ cjswd=cjswdn_hv18_snw     mjswd=0.31                pbswgd=0.8
+ cjswgd=cjswgdn_hv18_snw   mjswgd=0.36               tpb=0.002
+ tcj=0.0018                tpbsw=0.0025              tcjsw=0.0011
+ tpbswg=0.0028             tcjswg=0.00157            xtis=3
+ xtid=3                    dmcg=6.4e-08              dmci=6.4e-08
+ dmdg=0                    dmcgt=0                   dwj=0
+ xgw=0                     xgl=-1.09e-08             rshg=15.6
+ gbmin=1e-012              rbpb=50                   rbpd=50
+ rbps=50                   rbdb=50                   rbsb=50
+ ngcon=1                   lvsat=0+dlvsatn_hv18_snw  wnfactor=0+dwnfactorn_hv18_snw
+ lnfactor=0+dlnfactorn_hv18_snw                      pnfactor=0+dpnfactorn_hv18_snw
+ pvsat=0+dpvsatn_hv18_snw  wvsat=0+dwvsatn_hv18_snw  weta0=0+dweta0n_hv18_snw
+ lat=0+dlatn_hv18_snw      wat=0+dwatn_hv18_snw      pat=0+dpatn_hv18_snw
+ lagidl=0+dlagidln_hv18_snw                          wagidl=0+dwagidln_hv18_snw
+ pagidl=0+dpagidln_hv18_snw                          lbgidl=0+dlbgidln_hv18_snw
+ wbgidl=0+dwbgidln_hv18_snw                          pbgidl=0+dpbgidln_hv18_snw
+ minr=1e-3

// *********************************************************************************************
//
//                   *
//                                 1.8V PMOS HVMOS DEVICE MODELS
//                     *
//
//                   *
// *********************************************************************************************

     }
model pch_hv18_spw bsim4  {
     1: type=p
+ lmin=1e-005-dxlp_hv18_spw lmax=900.001e-6           wmin=2e-005-dxwp_hv18_spw
+ wmax=900.001e-6           version=4.5               binunit=2
+ paramchk=1                mobmod=0                  capmod=2
+ igcmod=0                  igbmod=0                  diomod=1
+ rdsmod=1                  rbodymod=0                rgeomod=1
+ rgatemod=1*rgflag_hv18_snw_spw                      permod=1
+ acnqsmod=0                trnqsmod=0                tempmod=0
+ tnom=25                   toxe=toxp_hv18_spw        toxm=3.85e-009
+ dtox=3.8e-010             epsrox=3.9                wint=0
+ lint=1.221e-007           ll=0                      wl=0
+ lln=1                     wln=1                     lw=0
+ ww=0                      lwn=1                     wwn=1
+ lwl=0                     wwl=0                     llc=0
+ wlc=0                     lwc=0                     wwc=0
+ lwlc=0                    wwlc=0                    xl=1e-08+dxlp_hv18_spw
+ xw=0+dxwp_hv18_spw        dlc=ddlcp_hv18_spw        dwc=0
+ xpart=1                   toxref=3e-009             dlcig=2.5e-009
+ vth0=-0.4494+dvthp_hv18_spw                         k1=0.332
+ k2=0.033448+dk2p_hv18_spw k3=-2.3465                k3b=1
+ w0=0                      dvt0=0.75418              dvt1=0.034455
+ dvt2=0                    dvt0w=0                   dvt1w=0
+ dvt2w=0                   dsub=0.4                  minv=-0.29832
+ voffl=-5e-009             dvtp0=2.5e-007            dvtp1=0.08
+ lpe0=1.4918e-007          lpeb=7.0022e-008          xj=8.5e-008
+ ngate=2.092e+020          ndep=6e+017               nsd=1e+020
+ phin=0.174                cdsc=0                    cdscb=0
+ cdscd=0                   cit=0.00086857+dcitp_hv18_spw
+ voff=-0.12184+dvoffp_hv18_spw                       nfactor=0.7+dnfactorp_hv18_spw
+ eta0=0.028556+deta0p_hv18_spw                       etab=-0.399
+ ud=0                      lud=0                     wud=0
+ pud=0                     u0=0.011522+du0p_hv18_spw ua=6.0334e-010
+ ub=1.0553e-018            uc=3.504e-011             vsat=160000+dvsatp_hv18_spw
+ a0=1.7871+da0p_hv18_spw   ags=0.49431+dagsp_hv18_spw
+ a1=0                      a2=1                      b0=0
+ b1=0                      keta=-0.044462            dwg=0
+ dwb=0                     pclm=0.34124              pdiblc1=0
+ pdiblc2=0.0001            pdiblcb=0                 drout=0.56
+ pvag=0                    delta=0.01                pscbe1=9.264e+008
+ pscbe2=1e-020             fprout=50                 pdits=0
+ pditsd=0                  rsh=15.2                  rsw=169.8
+ rdw=1980.2                prwg=0                    prwb=0
+ wr=1                      alpha0=1.5106e-08         alpha1=0.024473
+ beta0=30                  agidl=1e-007+dagidlp_hv18_spw
+ bgidl=9e+009+dbgidlp_hv18_spw                       cgidl=10
+ egidl=0.902               aigbacc=0.01238           bigbacc=0.006109
+ cigbacc=0.2809            nigbacc=4.05              aigbinv=0.35
+ bigbinv=0.03              cigbinv=0.006             eigbinv=1.1
+ nigbinv=1                 aigc=0.009898             bigc=0.001383
+ cigc=1.515e-005           aigsd=0.0086              bigsd=0.0004353
+ cigsd=3.925e-020          nigc=1                    poxedge=1
+ pigcd=1.672               ntox=1                    xrcrg1=12
+ xrcrg2=1                  cgso=cgsop_hv18_spw       cgdo=cgdop_hv18_spw
+ cgbo=0                    cgdl=cgdlp_hv18_spw       cgsl=cgslp_hv18_spw
+ clc=1e-007                cle=0.6                   cf=cfp_hv18_spw
+ ckappas=0.6               ckappad=0.6               acde=0.4
+ moin=6.5786               noff=2.289                voffcv=-0.0744
+ tvoff=0.0015              ltvoff=0                  wtvoff=0
+ ptvoff=0                  kt1=-0.21411001+dkt1p_hv18_spw
+ kt1l=0                    kt2=-0.011054             ute=-1
+ ua1=1.0258999e-010        ub1=3.9491994e-019        uc1=-7.0364998e-011
+ prt=0                     at=-4.5550949e-005+datp_hv18_spw
+ jss=1.67e-007             jsws=4.74e-013            jswgs=4.74e-013
+ njs=1.02                  njd=1.02                  ijthsfwd=0.01
+ ijthdfwd=0.01             ijthsrev=0.01             ijthdrev=0.01
+ bvs=8.2                   xjbvs=1                   xjbvd=1
+ jsd=1.57e-007             jswd=4.56e-013            jswgd=4.56e-013
+ bvd=14.2                  jtsswgs=1e-009+djtsswgsp_hv18_spw
+ jtsswgd=5e-008+djtsswgdp_hv18_spw                   njtsswg=8+dnjtsswgp_hv18_spw
+ xtsswgs=0.1               xtsswgd=0.45              tnjtsswg=1
+ vtsswgs=0.6               vtsswgd=0.1               pbs=0.5
+ cjs=cjsp_hv18_spw         mjs=0.24                  pbsws=0.9
+ cjsws=cjswsp_hv18_spw     mjsws=0.02                pbswgs=0.5
+ cjswgs=cjswgsp_hv18_spw   mjswgs=0.7                pbd=0.6
+ cjd=cjdp_hv18_spw         mjd=0.31                  pbswd=0.7
+ cjswd=cjswdp_hv18_spw     mjswd=0.35                pbswgd=0.8
+ cjswgd=cjswgdp_hv18_spw   mjswgd=0.43               tpb=0.00155
+ tcj=0.0011                tpbsw=0.0018              tcjsw=0.0011
+ tpbswg=0.0018             tcjswg=0.00118            xtis=3
+ xtid=3                    dmcg=6.4e-08              dmci=6.4e-08
+ dmdg=0                    dmcgt=0                   dwj=0
+ xgw=0                     xgl=-8.2e-09              rshg=14.1
+ gbmin=1e-012              rbpb=50                   rbpd=50
+ rbps=50                   rbdb=50                   rbsb=50
+ ngcon=1                   lvth0=0+dlvthp_hv18_spw   wvth0=0+dwvthp_hv18_spw
+ pvth0=0+dpvthp_hv18_spw   lu0=0+dlu0p_hv18_spw      wu0=0+dwu0p_hv18_spw
+ pu0=0+dpu0p_hv18_spw      la0=0+dla0p_hv18_spw      wa0=0+dwa0p_hv18_spw
+ pa0=0+dpa0p_hv18_spw      lags=0+dlagsp_hv18_spw    wags=0+dwagsp_hv18_spw
+ pags=0+dpagsp_hv18_spw    lvsat=0+dlvsatp_hv18_spw  wnfactor=0+dwnfactorp_hv18_spw
+ lnfactor=0+dlnfactorp_hv18_spw                      pnfactor=0+dpnfactorp_hv18_spw
+ pvsat=0+dpvsatp_hv18_spw  wvsat=0+dwvsatp_hv18_spw  lk2=0+dlk2p_hv18_spw
+ wk2=0+dwk2p_hv18_spw      pk2=0+dpk2p_hv18_spw      weta0=0+dweta0p_hv18_spw
+ lcit=0+dlcitp_hv18_spw    wcit=0+dwcitp_hv18_spw    pcit=0+dpcitp_hv18_spw
+ lvoff=0+dlvoffp_hv18_spw  wvoff=0+dwvoffp_hv18_spw  pvoff=0+dpvoffp_hv18_spw
+ lkt1=0+dlkt1p_hv18_spw    wkt1=0+dwkt1p_hv18_spw    pkt1=0+dpkt1p_hv18_spw
+ lat=0+dlatp_hv18_spw      wat=0+dwatp_hv18_spw      pat=0+dpatp_hv18_spw
+ lagidl=0+dlagidlp_hv18_spw                          wagidl=0+dwagidlp_hv18_spw
+ pagidl=0+dpagidlp_hv18_spw                          lbgidl=0+dlbgidlp_hv18_spw
+ wbgidl=0+dwbgidlp_hv18_spw                          pbgidl=0+dpbgidlp_hv18_spw
+ minr=1e-3

     2: type=p
+ lmin=1e-006-dxlp_hv18_spw lmax=1e-005-dxlp_hv18_spw wmin=2e-005-dxwp_hv18_spw
+ wmax=900.001e-6           version=4.5               binunit=2
+ paramchk=1                mobmod=0                  capmod=2
+ igcmod=0                  igbmod=0                  diomod=1
+ rdsmod=1                  rbodymod=0                rgeomod=1
+ rgatemod=1*rgflag_hv18_snw_spw                      permod=1
+ acnqsmod=0                trnqsmod=0                tempmod=0
+ tnom=25                   toxe=toxp_hv18_spw        toxm=3.85e-009
+ dtox=3.8e-010             epsrox=3.9                wint=0
+ lint=1.221e-007           ll=0                      wl=0
+ lln=1                     wln=1                     lw=0
+ ww=0                      lwn=1                     wwn=1
+ lwl=0                     wwl=0                     llc=0
+ wlc=0                     lwc=0                     wwc=0
+ lwlc=0                    wwlc=0                    xl=1e-08+dxlp_hv18_spw
+ xw=0+dxwp_hv18_spw        dlc=ddlcp_hv18_spw        dwc=0
+ xpart=1                   toxref=3e-009             dlcig=2.5e-009
+ vth0=-0.45002284+dvthp_hv18_spw                     lvth0=6.0826131e-009+dlvthp_hv18_spw
+ k1=0.332                  k2=0.032604013+dk2p_hv18_spw
+ lk2=8.2422965e-009+dlk2p_hv18_spw                   k3=-2.3465
+ k3b=1                     w0=0                      dvt0=0.75418
+ dvt1=0.034455             dvt2=0                    dvt0w=0
+ dvt1w=0                   dvt2w=0                   dsub=0.4
+ minv=-0.29832             voffl=-5e-009             dvtp0=2.5e-007
+ dvtp1=0.08                lpe0=1.4918e-007          lpeb=7.0022e-008
+ xj=8.5e-008               ngate=2.092e+020          ndep=6e+017
+ nsd=1e+020                phin=0.174                cdsc=0
+ cdscb=0                   cdscd=0                   cit=0.00085839267+dcitp_hv18_spw
+ lcit=9.9390777e-011+dlcitp_hv18_spw                 voff=-0.12359962+dvoffp_hv18_spw
+ lvoff=1.7184235e-008+dlvoffp_hv18_spw               nfactor=0.7+dnfactorp_hv18_spw
+ eta0=0.028556+deta0p_hv18_spw                       etab=-0.399
+ ud=0                      lud=0                     wud=0
+ pud=0                     u0=0.01149256+du0p_hv18_spw
+ lu0=2.8751228e-010+dlu0p_hv18_spw                   ua=6.0537872e-010
+ lua=-1.9909926e-017       ub=1.0582185e-018         lub=-2.8502272e-026
+ uc=3.1902729e-011         luc=3.0638273e-017        vsat=160000+dvsatp_hv18_spw
+ a0=1.8580251+da0p_hv18_spw                          la0=-6.9264714e-007+dla0p_hv18_spw
+ ags=0.45621017+dagsp_hv18_spw                       lags=3.7207912e-007+dlagsp_hv18_spw
+ a1=0                      a2=1                      b0=0
+ b1=0                      keta=-0.040876903         lketa=-3.5011695e-008
+ dwg=0                     dwb=0                     pclm=0.3454944
+ lpclm=-4.1548017e-008     pdiblc1=0                 pdiblc2=0.0001
+ pdiblcb=0                 drout=0.56                pvag=0
+ delta=0.01                pscbe1=9.264e+008         pscbe2=1e-020
+ fprout=50                 pdits=0                   pditsd=0
+ rsh=15.2                  rsw=169.8                 rdw=1980.2
+ prwg=0                    prwb=0                    wr=1
+ alpha0=1.5106e-08         alpha1=0.024473           beta0=30
+ agidl=1e-007+dagidlp_hv18_spw                       bgidl=9e+009+dbgidlp_hv18_spw
+ cgidl=10                  egidl=0.902               aigbacc=0.01238
+ bigbacc=0.006109          cigbacc=0.2809            nigbacc=4.05
+ aigbinv=0.35              bigbinv=0.03              cigbinv=0.006
+ eigbinv=1.1               nigbinv=1                 aigc=0.009898
+ bigc=0.001383             cigc=1.515e-005           aigsd=0.0086
+ bigsd=0.0004353           cigsd=3.925e-020          nigc=1
+ poxedge=1                 pigcd=1.672               ntox=1
+ xrcrg1=12                 xrcrg2=1                  cgso=cgsop_hv18_spw
+ cgdo=cgdop_hv18_spw       cgbo=0                    cgdl=cgdlp_hv18_spw
+ cgsl=cgslp_hv18_spw       clc=1e-007                cle=0.6
+ cf=cfp_hv18_spw           ckappas=0.6               ckappad=0.6
+ acde=0.4                  moin=6.5786               noff=2.289
+ voffcv=-0.0744            tvoff=0.0015              ltvoff=0
+ wtvoff=0                  ptvoff=0                  kt1=-0.20966672+dkt1p_hv18_spw
+ lkt1=-4.3392749e-008+dlkt1p_hv18_spw                kt1l=0
+ kt2=-0.0080724334         lkt2=-2.9117681e-008      ute=-0.97447362
+ lute=-2.492881e-007       ua1=4.2712751e-011        lua1=5.8475513e-016
+ ub1=5.7575905e-019        lub1=-1.7660567e-024      uc1=-7.8242525e-011
+ luc1=7.6931141e-017       prt=0                     at=17017.589+datp_hv18_spw
+ lat=-0.16619207+dlatp_hv18_spw                      jss=1.67e-007
+ jsws=4.74e-013            jswgs=4.74e-013           njs=1.02
+ njd=1.02                  ijthsfwd=0.01             ijthdfwd=0.01
+ ijthsrev=0.01             ijthdrev=0.01             bvs=8.2
+ xjbvs=1                   xjbvd=1                   jsd=1.57e-007
+ jswd=4.56e-013            jswgd=4.56e-013           bvd=14.2
+ jtsswgs=1e-009+djtsswgsp_hv18_spw                   jtsswgd=5e-008+djtsswgdp_hv18_spw
+ njtsswg=8+dnjtsswgp_hv18_spw                        xtsswgs=0.1
+ xtsswgd=0.45              tnjtsswg=1                vtsswgs=0.6
+ vtsswgd=0.1               pbs=0.5                   cjs=cjsp_hv18_spw
+ mjs=0.24                  pbsws=0.9                 cjsws=cjswsp_hv18_spw
+ mjsws=0.02                pbswgs=0.5                cjswgs=cjswgsp_hv18_spw
+ mjswgs=0.7                pbd=0.6                   cjd=cjdp_hv18_spw
+ mjd=0.31                  pbswd=0.7                 cjswd=cjswdp_hv18_spw
+ mjswd=0.35                pbswgd=0.8                cjswgd=cjswgdp_hv18_spw
+ mjswgd=0.43               tpb=0.00155               tcj=0.0011
+ tpbsw=0.0018              tcjsw=0.0011              tpbswg=0.0018
+ tcjswg=0.00118            xtis=3                    xtid=3
+ dmcg=6.4e-08              dmci=6.4e-08              dmdg=0
+ dmcgt=0                   dwj=0                     xgw=0
+ xgl=-8.2e-09              rshg=14.1                 gbmin=1e-012
+ rbpb=50                   rbpd=50                   rbps=50
+ rbdb=50                   rbsb=50                   ngcon=1
+ wvth0=0+dwvthp_hv18_spw   pvth0=0+dpvthp_hv18_spw   wu0=0+dwu0p_hv18_spw
+ pu0=0+dpu0p_hv18_spw      wa0=0+dwa0p_hv18_spw      pa0=0+dpa0p_hv18_spw
+ wags=0+dwagsp_hv18_spw    pags=0+dpagsp_hv18_spw    lvsat=0+dlvsatp_hv18_spw
+ wnfactor=0+dwnfactorp_hv18_spw                      lnfactor=0+dlnfactorp_hv18_spw
+ pnfactor=0+dpnfactorp_hv18_spw                      pvsat=0+dpvsatp_hv18_spw
+ wvsat=0+dwvsatp_hv18_spw  wk2=0+dwk2p_hv18_spw      pk2=0+dpk2p_hv18_spw
+ weta0=0+dweta0p_hv18_spw  wcit=0+dwcitp_hv18_spw    pcit=0+dpcitp_hv18_spw
+ wvoff=0+dwvoffp_hv18_spw  pvoff=0+dpvoffp_hv18_spw  wkt1=0+dwkt1p_hv18_spw
+ pkt1=0+dpkt1p_hv18_spw    wat=0+dwatp_hv18_spw      pat=0+dpatp_hv18_spw
+ lagidl=0+dlagidlp_hv18_spw                          wagidl=0+dwagidlp_hv18_spw
+ pagidl=0+dpagidlp_hv18_spw                          lbgidl=0+dlbgidlp_hv18_spw
+ wbgidl=0+dwbgidlp_hv18_spw                          pbgidl=0+dpbgidlp_hv18_spw
+ minr=1e-3

     3: type=p
+ lmin=8e-007-dxlp_hv18_spw lmax=1e-006-dxlp_hv18_spw wmin=2e-005-dxwp_hv18_spw
+ wmax=900.001e-6           version=4.5               binunit=2
+ paramchk=1                mobmod=0                  capmod=2
+ igcmod=0                  igbmod=0                  diomod=1
+ rdsmod=1                  rbodymod=0                rgeomod=1
+ rgatemod=1*rgflag_hv18_snw_spw                      permod=1
+ acnqsmod=0                trnqsmod=0                tempmod=0
+ tnom=25                   toxe=toxp_hv18_spw        toxm=3.85e-009
+ dtox=3.8e-010             epsrox=3.9                wint=0
+ lint=1.221e-007           ll=0                      wl=0
+ lln=1                     wln=1                     lw=0
+ ww=0                      lwn=1                     wwn=1
+ lwl=0                     wwl=0                     llc=0
+ wlc=0                     lwc=0                     wwc=0
+ lwlc=0                    wwlc=0                    xl=1e-08+dxlp_hv18_spw
+ xw=0+dxwp_hv18_spw        dlc=ddlcp_hv18_spw        dwc=0
+ xpart=1                   toxref=3e-009             dlcig=2.5e-009
+ vth0=-0.44174057+dvthp_hv18_spw                     lvth0=-2.5995212e-010+dlvthp_hv18_spw
+ k1=0.332                  k2=0.017563698+dk2p_hv18_spw
+ lk2=1.976017e-008+dlk2p_hv18_spw                    k3=-2.3465
+ k3b=1                     w0=0                      dvt0=0.75418
+ dvt1=0.034455             dvt2=0                    dvt0w=0
+ dvt1w=0                   dvt2w=0                   dsub=0.4
+ minv=-0.29832             voffl=-5e-009             dvtp0=2.5e-007
+ dvtp1=0.08                lpe0=1.4918e-007          lpeb=7.0022e-008
+ xj=8.5e-008               ngate=2.092e+020          ndep=6e+017
+ nsd=1e+020                phin=0.174                cdsc=0
+ cdscb=0                   cdscd=0                   cit=0.00077198517+dcitp_hv18_spw
+ lcit=1.6556164e-010+dlcitp_hv18_spw                 voff=-0.11223848+dvoffp_hv18_spw
+ lvoff=8.483874e-009+dlvoffp_hv18_spw                nfactor=0.7+dnfactorp_hv18_spw
+ eta0=0.028556+deta0p_hv18_spw                       etab=-0.399
+ ud=0                      lud=0                     wud=0
+ pud=0                     u0=0.011477598+du0p_hv18_spw
+ lu0=2.9896985e-010+dlu0p_hv18_spw                   ua=6.9098439e-010
+ lua=-8.546675e-017        ub=9.4122152e-019         lub=6.1094056e-026
+ uc=5.6133365e-011         luc=1.2082453e-017        vsat=160000+dvsatp_hv18_spw
+ a0=2.2366423+da0p_hv18_spw                          la0=-9.8259219e-007+dla0p_hv18_spw
+ ags=-0.54857668+dagsp_hv18_spw                      lags=1.1415449e-006+dlagsp_hv18_spw
+ a1=0                      a2=1                      b0=0
+ b1=0                      keta=0.0052163124         lketa=-7.030988e-008
+ dwg=0                     dwb=0                     pclm=0.14979
+ lpclm=1.0832241e-007      pdiblc1=0                 pdiblc2=0.0001
+ pdiblcb=0                 drout=0.56                pvag=0
+ delta=0.01                pscbe1=9.264e+008         pscbe2=1e-020
+ fprout=50                 pdits=0                   pditsd=0
+ rsh=15.2                  rsw=169.8                 rdw=1980.2
+ prwg=0                    prwb=0                    wr=1
+ alpha0=1.5106e-08         alpha1=0.024473           beta0=30
+ agidl=1e-007+dagidlp_hv18_spw                       bgidl=9e+009+dbgidlp_hv18_spw
+ cgidl=10                  egidl=0.902               aigbacc=0.01238
+ bigbacc=0.006109          cigbacc=0.2809            nigbacc=4.05
+ aigbinv=0.35              bigbinv=0.03              cigbinv=0.006
+ eigbinv=1.1               nigbinv=1                 aigc=0.009898
+ bigc=0.001383             cigc=1.515e-005           aigsd=0.0086
+ bigsd=0.0004353           cigsd=3.925e-020          nigc=1
+ poxedge=1                 pigcd=1.672               ntox=1
+ xrcrg1=12                 xrcrg2=1                  cgso=cgsop_hv18_spw
+ cgdo=cgdop_hv18_spw       cgbo=0                    cgdl=cgdlp_hv18_spw
+ cgsl=cgslp_hv18_spw       clc=1e-007                cle=0.6
+ cf=cfp_hv18_spw           ckappas=0.6               ckappad=0.6
+ acde=0.4                  moin=6.5786               noff=2.289
+ voffcv=-0.0744            tvoff=0.0015              ltvoff=0
+ wtvoff=0                  ptvoff=0                  kt1=-0.1711059+dkt1p_hv18_spw
+ lkt1=-7.2922625e-008+dlkt1p_hv18_spw                kt1l=0
+ kt2=-0.010613688          lkt2=-2.7171589e-008      ute=-1.3
+ ua1=-1.1765161e-010       lua1=7.0756216e-016       ub1=-1.090198e-018
+ lub1=-4.9026679e-025      uc1=-3.0075225e-011       luc1=4.0044622e-017
+ prt=0                     at=-200000+datp_hv18_spw  jss=1.67e-007
+ jsws=4.74e-013            jswgs=4.74e-013           njs=1.02
+ njd=1.02                  ijthsfwd=0.01             ijthdfwd=0.01
+ ijthsrev=0.01             ijthdrev=0.01             bvs=8.2
+ xjbvs=1                   xjbvd=1                   jsd=1.57e-007
+ jswd=4.56e-013            jswgd=4.56e-013           bvd=14.2
+ jtsswgs=1e-009+djtsswgsp_hv18_spw                   jtsswgd=5e-008+djtsswgdp_hv18_spw
+ njtsswg=8+dnjtsswgp_hv18_spw                        xtsswgs=0.1
+ xtsswgd=0.45              tnjtsswg=1                vtsswgs=0.6
+ vtsswgd=0.1               pbs=0.5                   cjs=cjsp_hv18_spw
+ mjs=0.24                  pbsws=0.9                 cjsws=cjswsp_hv18_spw
+ mjsws=0.02                pbswgs=0.5                cjswgs=cjswgsp_hv18_spw
+ mjswgs=0.7                pbd=0.6                   cjd=cjdp_hv18_spw
+ mjd=0.31                  pbswd=0.7                 cjswd=cjswdp_hv18_spw
+ mjswd=0.35                pbswgd=0.8                cjswgd=cjswgdp_hv18_spw
+ mjswgd=0.43               tpb=0.00155               tcj=0.0011
+ tpbsw=0.0018              tcjsw=0.0011              tpbswg=0.0018
+ tcjswg=0.00118            xtis=3                    xtid=3
+ dmcg=6.4e-08              dmci=6.4e-08              dmdg=0
+ dmcgt=0                   dwj=0                     xgw=0
+ xgl=-8.2e-09              rshg=14.1                 gbmin=1e-012
+ rbpb=50                   rbpd=50                   rbps=50
+ rbdb=50                   rbsb=50                   ngcon=1
+ wvth0=0+dwvthp_hv18_spw   pvth0=0+dpvthp_hv18_spw   wu0=0+dwu0p_hv18_spw
+ pu0=0+dpu0p_hv18_spw      wa0=0+dwa0p_hv18_spw      pa0=0+dpa0p_hv18_spw
+ wags=0+dwagsp_hv18_spw    pags=0+dpagsp_hv18_spw    lvsat=0+dlvsatp_hv18_spw
+ wnfactor=0+dwnfactorp_hv18_spw                      lnfactor=0+dlnfactorp_hv18_spw
+ pnfactor=0+dpnfactorp_hv18_spw                      pvsat=0+dpvsatp_hv18_spw
+ wvsat=0+dwvsatp_hv18_spw  wk2=0+dwk2p_hv18_spw      pk2=0+dpk2p_hv18_spw
+ weta0=0+dweta0p_hv18_spw  wcit=0+dwcitp_hv18_spw    pcit=0+dpcitp_hv18_spw
+ wvoff=0+dwvoffp_hv18_spw  pvoff=0+dpvoffp_hv18_spw  wkt1=0+dwkt1p_hv18_spw
+ pkt1=0+dpkt1p_hv18_spw    lat=0+dlatp_hv18_spw      wat=0+dwatp_hv18_spw
+ pat=0+dpatp_hv18_spw      lagidl=0+dlagidlp_hv18_spw
+ wagidl=0+dwagidlp_hv18_spw                          pagidl=0+dpagidlp_hv18_spw
+ lbgidl=0+dlbgidlp_hv18_spw                          wbgidl=0+dwbgidlp_hv18_spw
+ pbgidl=0+dpbgidlp_hv18_spw                          minr=1e-3

     4: type=p
+ lmin=7e-007-dxlp_hv18_spw lmax=8e-007-dxlp_hv18_spw wmin=2e-005-dxwp_hv18_spw
+ wmax=900.001e-6           version=4.5               binunit=2
+ paramchk=1                mobmod=0                  capmod=2
+ igcmod=0                  igbmod=0                  diomod=1
+ rdsmod=1                  rbodymod=0                rgeomod=1
+ rgatemod=1*rgflag_hv18_snw_spw                      permod=1
+ acnqsmod=0                trnqsmod=0                tempmod=0
+ tnom=25                   toxe=toxp_hv18_spw        toxm=3.85e-009
+ dtox=3.8e-010             epsrox=3.9                wint=0
+ lint=1.221e-007           ll=0                      wl=0
+ lln=1                     wln=1                     lw=0
+ ww=0                      lwn=1                     wwn=1
+ lwl=0                     wwl=0                     llc=0
+ wlc=0                     lwc=0                     wwc=0
+ lwlc=0                    wwlc=0                    xl=1e-08+dxlp_hv18_spw
+ xw=0+dxwp_hv18_spw        dlc=ddlcp_hv18_spw        dwc=0
+ xpart=1                   toxref=3e-009             dlcig=2.5e-009
+ vth0=-0.45244738+dvthp_hv18_spw                     lvth0=5.7979603e-009+dlvthp_hv18_spw
+ k1=0.332                  k2=0.053433568+dk2p_hv18_spw
+ lk2=-5.3500313e-010+dlk2p_hv18_spw                  k3=-2.3465
+ k3b=1                     w0=0                      dvt0=0.75418
+ dvt1=0.034455             dvt2=0                    dvt0w=0
+ dvt1w=0                   dvt2w=0                   dsub=0.4
+ minv=-0.29832             voffl=-5e-009             dvtp0=2.5e-007
+ dvtp1=0.08                lpe0=1.4918e-007          lpeb=7.0022e-008
+ xj=8.5e-008               ngate=2.092e+020          ndep=6e+017
+ nsd=1e+020                phin=0.174                cdsc=0
+ cdscb=0                   cdscd=0                   cit=0.0013655136+dcitp_hv18_spw
+ lcit=-1.7025676e-010+dlcitp_hv18_spw                voff=-0.10769628+dvoffp_hv18_spw
+ lvoff=5.9139011e-009+dlvoffp_hv18_spw               nfactor=0.7+dnfactorp_hv18_spw
+ eta0=0.028556+deta0p_hv18_spw                       etab=-0.399
+ ud=0                      lud=0                     wud=0
+ pud=0                     u0=0.012648809+du0p_hv18_spw
+ lu0=-3.6370114e-010+dlu0p_hv18_spw                  ua=1.065866e-009
+ lua=-2.975748e-016        ub=8.5170143e-019         lub=1.1174452e-025
+ uc=1.0450441e-010         luc=-1.5285884e-017       vsat=160000+dvsatp_hv18_spw
+ a0=1.4316025+da0p_hv18_spw                          la0=-5.271007e-007+dla0p_hv18_spw
+ ags=-2.2247935+dagsp_hv18_spw                       lags=2.0899484e-006+dlagsp_hv18_spw
+ a1=0                      a2=1                      b0=0
+ b1=0                      keta=-0.0766622           lketa=-2.3983017e-008
+ dwg=0                     dwb=0                     pclm=0.34124
+ pdiblc1=0                 pdiblc2=0.0001            pdiblcb=0
+ drout=0.56                pvag=0                    delta=0.01
+ pscbe1=9.264e+008         pscbe2=1e-020             fprout=50
+ pdits=0                   pditsd=0                  rsh=15.2
+ rsw=169.8                 rdw=1980.2                prwg=0
+ prwb=0                    wr=1                      alpha0=1.5106e-08
+ alpha1=0.024473           beta0=30                  agidl=1e-007+dagidlp_hv18_spw
+ bgidl=9e+009+dbgidlp_hv18_spw                       cgidl=10
+ egidl=0.902               aigbacc=0.01238           bigbacc=0.006109
+ cigbacc=0.2809            nigbacc=4.05              aigbinv=0.35
+ bigbinv=0.03              cigbinv=0.006             eigbinv=1.1
+ nigbinv=1                 aigc=0.009898             bigc=0.001383
+ cigc=1.515e-005           aigsd=0.0086              bigsd=0.0004353
+ cigsd=3.925e-020          nigc=1                    poxedge=1
+ pigcd=1.672               ntox=1                    xrcrg1=12
+ xrcrg2=1                  cgso=cgsop_hv18_spw       cgdo=cgdop_hv18_spw
+ cgbo=0                    cgdl=cgdlp_hv18_spw       cgsl=cgslp_hv18_spw
+ clc=1e-007                cle=0.6                   cf=cfp_hv18_spw
+ ckappas=0.6               ckappad=0.6               acde=0.4
+ moin=6.5786               noff=2.289                voffcv=-0.0744
+ tvoff=0.0015              ltvoff=0                  wtvoff=0
+ ptvoff=0                  kt1=-0.34647684+dkt1p_hv18_spw
+ lkt1=2.6302254e-008+dlkt1p_hv18_spw                 kt1l=0
+ kt2=-0.18871161           lkt2=7.3596216e-008       ute=-1.3
+ ua1=5.7594624e-009        lua1=-2.6177089e-015      ub1=-9.8112536e-018
+ lub1=4.4441065e-024       uc1=-2.6351929e-011       luc1=3.7937981e-017
+ prt=0                     at=32900+datp_hv18_spw    lat=-0.13177482+dlatp_hv18_spw
+ jss=1.67e-007             jsws=4.74e-013            jswgs=4.74e-013
+ njs=1.02                  njd=1.02                  ijthsfwd=0.01
+ ijthdfwd=0.01             ijthsrev=0.01             ijthdrev=0.01
+ bvs=8.2                   xjbvs=1                   xjbvd=1
+ jsd=1.57e-007             jswd=4.56e-013            jswgd=4.56e-013
+ bvd=14.2                  jtsswgs=1e-009+djtsswgsp_hv18_spw
+ jtsswgd=5e-008+djtsswgdp_hv18_spw                   njtsswg=8+dnjtsswgp_hv18_spw
+ xtsswgs=0.1               xtsswgd=0.45              tnjtsswg=1
+ vtsswgs=0.6               vtsswgd=0.1               pbs=0.5
+ cjs=cjsp_hv18_spw         mjs=0.24                  pbsws=0.9
+ cjsws=cjswsp_hv18_spw     mjsws=0.02                pbswgs=0.5
+ cjswgs=cjswgsp_hv18_spw   mjswgs=0.7                pbd=0.6
+ cjd=cjdp_hv18_spw         mjd=0.31                  pbswd=0.7
+ cjswd=cjswdp_hv18_spw     mjswd=0.35                pbswgd=0.8
+ cjswgd=cjswgdp_hv18_spw   mjswgd=0.43               tpb=0.00155
+ tcj=0.0011                tpbsw=0.0018              tcjsw=0.0011
+ tpbswg=0.0018             tcjswg=0.00118            xtis=3
+ xtid=3                    dmcg=6.4e-08              dmci=6.4e-08
+ dmdg=0                    dmcgt=0                   dwj=0
+ xgw=0                     xgl=-8.2e-09              rshg=14.1
+ gbmin=1e-012              rbpb=50                   rbpd=50
+ rbps=50                   rbdb=50                   rbsb=50
+ ngcon=1                   wvth0=0+dwvthp_hv18_spw   pvth0=0+dpvthp_hv18_spw
+ wu0=0+dwu0p_hv18_spw      pu0=0+dpu0p_hv18_spw      wa0=0+dwa0p_hv18_spw
+ pa0=0+dpa0p_hv18_spw      wags=0+dwagsp_hv18_spw    pags=0+dpagsp_hv18_spw
+ lvsat=0+dlvsatp_hv18_spw  wnfactor=0+dwnfactorp_hv18_spw
+ lnfactor=0+dlnfactorp_hv18_spw                      pnfactor=0+dpnfactorp_hv18_spw
+ pvsat=0+dpvsatp_hv18_spw  wvsat=0+dwvsatp_hv18_spw  wk2=0+dwk2p_hv18_spw
+ pk2=0+dpk2p_hv18_spw      weta0=0+dweta0p_hv18_spw  wcit=0+dwcitp_hv18_spw
+ pcit=0+dpcitp_hv18_spw    wvoff=0+dwvoffp_hv18_spw  pvoff=0+dpvoffp_hv18_spw
+ wkt1=0+dwkt1p_hv18_spw    pkt1=0+dpkt1p_hv18_spw    wat=0+dwatp_hv18_spw
+ pat=0+dpatp_hv18_spw      lagidl=0+dlagidlp_hv18_spw
+ wagidl=0+dwagidlp_hv18_spw                          pagidl=0+dpagidlp_hv18_spw
+ lbgidl=0+dlbgidlp_hv18_spw                          wbgidl=0+dwbgidlp_hv18_spw
+ pbgidl=0+dpbgidlp_hv18_spw                          minr=1e-3

     5: type=p
+ lmin=0.594e-06            lmax=7e-007-dxlp_hv18_spw wmin=2e-005-dxwp_hv18_spw
+ wmax=900.001e-6           version=4.5               binunit=2
+ paramchk=1                mobmod=0                  capmod=2
+ igcmod=0                  igbmod=0                  diomod=1
+ rdsmod=1                  rbodymod=0                rgeomod=1
+ rgatemod=1*rgflag_hv18_snw_spw                      permod=1
+ acnqsmod=0                trnqsmod=0                tempmod=0
+ tnom=25                   toxe=toxp_hv18_spw        toxm=3.85e-009
+ dtox=3.8e-010             epsrox=3.9                wint=0
+ lint=1.221e-007           ll=0                      wl=0
+ lln=1                     wln=1                     lw=0
+ ww=0                      lwn=1                     wwn=1
+ lwl=0                     wwl=0                     llc=0
+ wlc=0                     lwc=0                     wwc=0
+ lwlc=0                    wwlc=0                    xl=1e-08+dxlp_hv18_spw
+ xw=0+dxwp_hv18_spw        dlc=ddlcp_hv18_spw        dwc=0
+ xpart=1                   toxref=3e-009             dlcig=2.5e-009
+ vth0=-0.46000954+dvthp_hv18_spw                     lvth0=9.3204155e-009+dlvthp_hv18_spw
+ k1=0.332                  k2=0.090891528+dk2p_hv18_spw
+ lk2=-1.7982921e-008+dlk2p_hv18_spw                  k3=-2.3465
+ k3b=1                     w0=0                      dvt0=0.75418
+ dvt1=0.034455             dvt2=0                    dvt0w=0
+ dvt1w=0                   dvt2w=0                   dsub=0.4
+ minv=-0.2953936           lminv=-1.3631171e-009     voffl=-5e-009
+ dvtp0=2.5e-007            dvtp1=0.08                lpe0=1.4918e-007
+ lpeb=7.0022e-008          xj=8.5e-008               ngate=2.092e+020
+ ndep=6e+017               nsd=1e+020                phin=0.174
+ cdsc=0                    cdscb=0                   cdscd=0
+ cit=0.00031777788+dcitp_hv18_spw                    lcit=3.1777855e-010+dlcitp_hv18_spw
+ voff=-0.11891263+dvoffp_hv18_spw                    lvoff=1.1138475e-008+dlvoffp_hv18_spw
+ nfactor=0.7+dnfactorp_hv18_spw                      eta0=0.028556+deta0p_hv18_spw
+ etab=-0.399               ud=0                      lud=0
+ wud=0                     pud=0                     u0=0.011385139+du0p_hv18_spw
+ lu0=2.2491603e-010+dlu0p_hv18_spw                   ua=1.302486e-009
+ lua=-4.0779237e-016       ub=1.1024471e-020         lub=5.0333185e-025
+ uc=1.0795706e-010         luc=-1.6894131e-017       vsat=160000+dvsatp_hv18_spw
+ a0=0.29999764+da0p_hv18_spw                         la0=8.519482e-013+dla0p_hv18_spw
+ ags=-3.2520722+dagsp_hv18_spw                       lags=2.5684548e-006+dlagsp_hv18_spw
+ a1=0                      a2=1                      b0=0
+ b1=0                      keta=-0.11384722          lketa=-6.6622349e-009
+ dwg=0                     dwb=0                     pclm=0.34577588
+ lpclm=-2.1128145e-009     pdiblc1=0                 pdiblc2=0.0001
+ pdiblcb=0                 drout=0.56                pvag=0
+ delta=0.01                pscbe1=9.264e+008         pscbe2=1e-020
+ fprout=50                 pdits=0                   pditsd=0
+ rsh=15.2                  rsw=169.8                 rdw=1980.2
+ prwg=0                    prwb=0                    wr=1
+ alpha0=1.5106e-08         alpha1=0.024473           beta0=30
+ agidl=1e-007+dagidlp_hv18_spw                       bgidl=9e+009+dbgidlp_hv18_spw
+ cgidl=10                  egidl=0.902               aigbacc=0.01238
+ bigbacc=0.006109          cigbacc=0.2809            nigbacc=4.05
+ aigbinv=0.35              bigbinv=0.03              cigbinv=0.006
+ eigbinv=1.1               nigbinv=1                 aigc=0.009898
+ bigc=0.001383             cigc=1.515e-005           aigsd=0.0086
+ bigsd=0.0004353           cigsd=3.925e-020          nigc=1
+ poxedge=1                 pigcd=1.672               ntox=1
+ xrcrg1=12                 xrcrg2=1                  cgso=cgsop_hv18_spw
+ cgdo=cgdop_hv18_spw       cgbo=0                    cgdl=cgdlp_hv18_spw
+ cgsl=cgslp_hv18_spw       clc=1e-007                cle=0.6
+ cf=cfp_hv18_spw           ckappas=0.6               ckappad=0.6
+ acde=0.4                  moin=6.5786               noff=2.289
+ voffcv=-0.0744            tvoff=0.0015              ltvoff=0
+ wtvoff=0                  ptvoff=0                  kt1=-0.2084366+dkt1p_hv18_spw
+ lkt1=-3.799689e-008+dlkt1p_hv18_spw                 kt1l=0
+ kt2=0.0073311794          lkt2=-1.7720516e-008      ute=-1.3
+ ua1=-1.7694277e-009       lua1=8.8924804e-016       ub1=1.705201e-018
+ lub1=-9.2025805e-025      uc1=-1.1399603e-010       luc1=7.8762604e-017
+ prt=0                     at=-250000+datp_hv18_spw  jss=1.67e-007
+ jsws=4.74e-013            jswgs=4.74e-013           njs=1.02
+ njd=1.02                  ijthsfwd=0.01             ijthdfwd=0.01
+ ijthsrev=0.01             ijthdrev=0.01             bvs=8.2
+ xjbvs=1                   xjbvd=1                   jsd=1.57e-007
+ jswd=4.56e-013            jswgd=4.56e-013           bvd=14.2
+ jtsswgs=1e-009+djtsswgsp_hv18_spw                   jtsswgd=5e-008+djtsswgdp_hv18_spw
+ njtsswg=8+dnjtsswgp_hv18_spw                        xtsswgs=0.1
+ xtsswgd=0.45              tnjtsswg=1                vtsswgs=0.6
+ vtsswgd=0.1               pbs=0.5                   cjs=cjsp_hv18_spw
+ mjs=0.24                  pbsws=0.9                 cjsws=cjswsp_hv18_spw
+ mjsws=0.02                pbswgs=0.5                cjswgs=cjswgsp_hv18_spw
+ mjswgs=0.7                pbd=0.6                   cjd=cjdp_hv18_spw
+ mjd=0.31                  pbswd=0.7                 cjswd=cjswdp_hv18_spw
+ mjswd=0.35                pbswgd=0.8                cjswgd=cjswgdp_hv18_spw
+ mjswgd=0.43               tpb=0.00155               tcj=0.0011
+ tpbsw=0.0018              tcjsw=0.0011              tpbswg=0.0018
+ tcjswg=0.00118            xtis=3                    xtid=3
+ dmcg=6.4e-08              dmci=6.4e-08              dmdg=0
+ dmcgt=0                   dwj=0                     xgw=0
+ xgl=-8.2e-09              rshg=14.1                 gbmin=1e-012
+ rbpb=50                   rbpd=50                   rbps=50
+ rbdb=50                   rbsb=50                   ngcon=1
+ wvth0=0+dwvthp_hv18_spw   pvth0=0+dpvthp_hv18_spw   wu0=0+dwu0p_hv18_spw
+ pu0=0+dpu0p_hv18_spw      wa0=0+dwa0p_hv18_spw      pa0=0+dpa0p_hv18_spw
+ wags=0+dwagsp_hv18_spw    pags=0+dpagsp_hv18_spw    lvsat=0+dlvsatp_hv18_spw
+ wnfactor=0+dwnfactorp_hv18_spw                      lnfactor=0+dlnfactorp_hv18_spw
+ pnfactor=0+dpnfactorp_hv18_spw                      pvsat=0+dpvsatp_hv18_spw
+ wvsat=0+dwvsatp_hv18_spw  wk2=0+dwk2p_hv18_spw      pk2=0+dpk2p_hv18_spw
+ weta0=0+dweta0p_hv18_spw  wcit=0+dwcitp_hv18_spw    pcit=0+dpcitp_hv18_spw
+ wvoff=0+dwvoffp_hv18_spw  pvoff=0+dpvoffp_hv18_spw  wkt1=0+dwkt1p_hv18_spw
+ pkt1=0+dpkt1p_hv18_spw    lat=0+dlatp_hv18_spw      wat=0+dwatp_hv18_spw
+ pat=0+dpatp_hv18_spw      lagidl=0+dlagidlp_hv18_spw
+ wagidl=0+dwagidlp_hv18_spw                          pagidl=0+dpagidlp_hv18_spw
+ lbgidl=0+dlbgidlp_hv18_spw                          wbgidl=0+dwbgidlp_hv18_spw
+ pbgidl=0+dpbgidlp_hv18_spw                          minr=1e-3

     6: type=p
+ lmin=1e-005-dxlp_hv18_spw lmax=900.001e-6           wmin=1e-005-dxwp_hv18_spw
+ wmax=2e-005-dxwp_hv18_spw version=4.5               binunit=2
+ paramchk=1                mobmod=0                  capmod=2
+ igcmod=0                  igbmod=0                  diomod=1
+ rdsmod=1                  rbodymod=0                rgeomod=1
+ rgatemod=1*rgflag_hv18_snw_spw                      permod=1
+ acnqsmod=0                trnqsmod=0                tempmod=0
+ tnom=25                   toxe=toxp_hv18_spw        toxm=3.85e-009
+ dtox=3.8e-010             epsrox=3.9                wint=0
+ lint=1.221e-007           ll=0                      wl=0
+ lln=1                     wln=1                     lw=0
+ ww=0                      lwn=1                     wwn=1
+ lwl=0                     wwl=0                     llc=0
+ wlc=0                     lwc=0                     wwc=0
+ lwlc=0                    wwlc=0                    xl=1e-08+dxlp_hv18_spw
+ xw=0+dxwp_hv18_spw        dlc=ddlcp_hv18_spw        dwc=0
+ xpart=1                   toxref=3e-009             dlcig=2.5e-009
+ vth0=-0.45229996+dvthp_hv18_spw                     wvth0=5.799951e-008+dwvthp_hv18_spw
+ k1=0.332                  k2=0.035119993+dk2p_hv18_spw
+ wk2=-3.3440033e-008+dwk2p_hv18_spw                  k3=-2.3465
+ k3b=1                     w0=0                      dvt0=0.75418
+ dvt1=0.034455             dvt2=0                    dvt0w=0
+ dvt1w=0                   dvt2w=0                   dsub=0.4
+ minv=-0.29832             voffl=-5e-009             dvtp0=2.5e-007
+ dvtp1=0.08                lpe0=1.4918e-007          lpeb=7.0022e-008
+ xj=8.5e-008               ngate=2.092e+020          ndep=6e+017
+ nsd=1e+020                phin=0.174                cdsc=0
+ cdscb=0                   cdscd=0                   cit=0.00077880101+dcitp_hv18_spw
+ wcit=1.7953888e-009+dwcitp_hv18_spw                 voff=-0.12547995+dvoffp_hv18_spw
+ wvoff=7.2799436e-008+dwvoffp_hv18_spw               nfactor=0.7+dnfactorp_hv18_spw
+ eta0=0.028556+deta0p_hv18_spw                       etab=-0.39999999
+ wetab=1.99999e-008        ud=0                      lud=0
+ wud=0                     pud=0                     u0=0.011583999+du0p_hv18_spw
+ wu0=-1.2399938e-009+dwu0p_hv18_spw                  ua=5.9867005e-010
+ wua=9.3399533e-017        ub=1.0542001e-018         wub=2.199789e-026
+ uc=3.7942019e-011         wuc=-5.804067e-017        vsat=160000+dvsatp_hv18_spw
+ a0=1.6242008+da0p_hv18_spw                          wa0=3.2579997e-006+dwa0p_hv18_spw
+ ags=0.4536209+dagsp_hv18_spw                        wags=8.1378613e-007+dwagsp_hv18_spw
+ a1=0                      a2=1                      b0=0
+ b1=0                      keta=-0.046452016         wketa=3.9800521e-008
+ dwg=0                     dwb=0                     pclm=0.34124
+ pdiblc1=0                 pdiblc2=0.0001            pdiblcb=0
+ drout=0.56                pvag=0                    delta=0.01
+ pscbe1=9.264e+008         pscbe2=1e-020             fprout=50
+ pdits=0                   pditsd=0                  rsh=15.2
+ rsw=169.8                 rdw=1980.2                prwg=0
+ prwb=0                    wr=1                      alpha0=1.5106e-08
+ alpha1=0.024473           beta0=30                  agidl=1e-007+dagidlp_hv18_spw
+ bgidl=9e+009+dbgidlp_hv18_spw                       cgidl=10
+ egidl=0.902               aigbacc=0.01238           bigbacc=0.006109
+ cigbacc=0.2809            nigbacc=4.05              aigbinv=0.35
+ bigbinv=0.03              cigbinv=0.006             eigbinv=1.1
+ nigbinv=1                 aigc=0.009898             bigc=0.001383
+ cigc=1.515e-005           aigsd=0.0086              bigsd=0.0004353
+ cigsd=3.925e-020          nigc=1                    poxedge=1
+ pigcd=1.672               ntox=1                    xrcrg1=12
+ xrcrg2=1                  cgso=cgsop_hv18_spw       cgdo=cgdop_hv18_spw
+ cgbo=0                    cgdl=cgdlp_hv18_spw       cgsl=cgslp_hv18_spw
+ clc=1e-007                cle=0.6                   cf=cfp_hv18_spw
+ ckappas=0.6               ckappad=0.6               acde=0.4
+ moin=6.5786               noff=2.289                voffcv=-0.0744
+ tvoff=0.0015              ltvoff=0                  wtvoff=0
+ ptvoff=0                  kt1=-0.18234034+dkt1p_hv18_spw
+ wkt1=-6.3539662e-007+dwkt1p_hv18_spw                kt1l=0
+ kt2=0.0014928745          wkt2=-2.5093875e-007      ute=-1
+ ua1=-5.2240377e-010       wua1=1.2499938e-014       ub1=1.0153537e-018
+ wub1=-1.2408737e-023      uc1=7.239228e-012         wuc1=-1.5520923e-015
+ prt=0                     at=0.00041671068+datp_hv18_spw
+ wat=-9.2452788e-009+dwatp_hv18_spw                  jss=1.67e-007
+ jsws=4.74e-013            jswgs=4.74e-013           njs=1.02
+ njd=1.02                  ijthsfwd=0.01             ijthdfwd=0.01
+ ijthsrev=0.01             ijthdrev=0.01             bvs=8.2
+ xjbvs=1                   xjbvd=1                   jsd=1.57e-007
+ jswd=4.56e-013            jswgd=4.56e-013           bvd=14.2
+ jtsswgs=1e-009+djtsswgsp_hv18_spw                   jtsswgd=5e-008+djtsswgdp_hv18_spw
+ njtsswg=8+dnjtsswgp_hv18_spw                        xtsswgs=0.1
+ xtsswgd=0.45              tnjtsswg=1                vtsswgs=0.6
+ vtsswgd=0.1               pbs=0.5                   cjs=cjsp_hv18_spw
+ mjs=0.24                  pbsws=0.9                 cjsws=cjswsp_hv18_spw
+ mjsws=0.02                pbswgs=0.5                cjswgs=cjswgsp_hv18_spw
+ mjswgs=0.7                pbd=0.6                   cjd=cjdp_hv18_spw
+ mjd=0.31                  pbswd=0.7                 cjswd=cjswdp_hv18_spw
+ mjswd=0.35                pbswgd=0.8                cjswgd=cjswgdp_hv18_spw
+ mjswgd=0.43               tpb=0.00155               tcj=0.0011
+ tpbsw=0.0018              tcjsw=0.0011              tpbswg=0.0018
+ tcjswg=0.00118            xtis=3                    xtid=3
+ dmcg=6.4e-08              dmci=6.4e-08              dmdg=0
+ dmcgt=0                   dwj=0                     xgw=0
+ xgl=-8.2e-09              rshg=14.1                 gbmin=1e-012
+ rbpb=50                   rbpd=50                   rbps=50
+ rbdb=50                   rbsb=50                   ngcon=1
+ lvth0=0+dlvthp_hv18_spw   pvth0=0+dpvthp_hv18_spw   lu0=0+dlu0p_hv18_spw
+ pu0=0+dpu0p_hv18_spw      la0=0+dla0p_hv18_spw      pa0=0+dpa0p_hv18_spw
+ lags=0+dlagsp_hv18_spw    pags=0+dpagsp_hv18_spw    lvsat=0+dlvsatp_hv18_spw
+ wnfactor=0+dwnfactorp_hv18_spw                      lnfactor=0+dlnfactorp_hv18_spw
+ pnfactor=0+dpnfactorp_hv18_spw                      pvsat=0+dpvsatp_hv18_spw
+ wvsat=0+dwvsatp_hv18_spw  lk2=0+dlk2p_hv18_spw      pk2=0+dpk2p_hv18_spw
+ weta0=0+dweta0p_hv18_spw  lcit=0+dlcitp_hv18_spw    pcit=0+dpcitp_hv18_spw
+ lvoff=0+dlvoffp_hv18_spw  pvoff=0+dpvoffp_hv18_spw  lkt1=0+dlkt1p_hv18_spw
+ pkt1=0+dpkt1p_hv18_spw    lat=0+dlatp_hv18_spw      pat=0+dpatp_hv18_spw
+ lagidl=0+dlagidlp_hv18_spw                          wagidl=0+dwagidlp_hv18_spw
+ pagidl=0+dpagidlp_hv18_spw                          lbgidl=0+dlbgidlp_hv18_spw
+ wbgidl=0+dwbgidlp_hv18_spw                          pbgidl=0+dpbgidlp_hv18_spw
+ minr=1e-3

     7: type=p
+ lmin=1e-006-dxlp_hv18_spw lmax=1e-005-dxlp_hv18_spw wmin=1e-005-dxwp_hv18_spw
+ wmax=2e-005-dxwp_hv18_spw version=4.5               binunit=2
+ paramchk=1                mobmod=0                  capmod=2
+ igcmod=0                  igbmod=0                  diomod=1
+ rdsmod=1                  rbodymod=0                rgeomod=1
+ rgatemod=1*rgflag_hv18_snw_spw                      permod=1
+ acnqsmod=0                trnqsmod=0                tempmod=0
+ tnom=25                   toxe=toxp_hv18_spw        toxm=3.85e-009
+ dtox=3.8e-010             epsrox=3.9                wint=0
+ lint=1.221e-007           ll=0                      wl=0
+ lln=1                     wln=1                     lw=0
+ ww=0                      lwn=1                     wwn=1
+ lwl=0                     wwl=0                     llc=0
+ wlc=0                     lwc=0                     wwc=0
+ lwlc=0                    wwlc=0                    xl=1e-08+dxlp_hv18_spw
+ xw=0+dxwp_hv18_spw        dlc=ddlcp_hv18_spw        dwc=0
+ xpart=1                   toxref=3e-009             dlcig=2.5e-009
+ vth0=-0.45286749+dvthp_hv18_spw                     lvth0=5.5424694e-009+dlvthp_hv18_spw
+ wvth0=5.6893321e-008+dwvthp_hv18_spw                pvth0=1.0802929e-014+dpvthp_hv18_spw
+ k1=0.332                  k2=0.034389938+dk2p_hv18_spw
+ lk2=7.1296443e-009+dlk2p_hv18_spw                   wk2=-3.5718692e-008+dwk2p_hv18_spw
+ pk2=2.2253156e-014+dpk2p_hv18_spw                   k3=-2.3465
+ k3b=1                     w0=0                      dvt0=0.75418
+ dvt1=0.034455             dvt2=0                    dvt0w=0
+ dvt1w=0                   dvt2w=0                   dsub=0.4
+ minv=-0.29832             voffl=-5e-009             dvtp0=2.5e-007
+ dvtp1=0.08                lpe0=1.4918e-007          lpeb=7.0022e-008
+ xj=8.5e-008               ngate=2.092e+020          ndep=6e+017
+ nsd=1e+020                phin=0.174                cdsc=0
+ cdscb=0                   cdscd=0                   cit=0.00076910447+dcitp_hv18_spw
+ lcit=9.4695416e-011+dlcitp_hv18_spw                 wcit=1.7857729e-009+dwcitp_hv18_spw
+ pcit=9.3907689e-017+dpcitp_hv18_spw                 voff=-0.12704991+dvoffp_hv18_spw
+ lvoff=1.5332004e-008+dlvoffp_hv18_spw               wvoff=6.9006154e-008+dwvoffp_hv18_spw
+ pvoff=3.7044808e-014+dpvoffp_hv18_spw               nfactor=0.7+dnfactorp_hv18_spw
+ eta0=0.028556+deta0p_hv18_spw                       etab=-0.39999999
+ wetab=1.99999e-008        ud=0                      lud=0
+ wud=0                     pud=0                     u0=0.011559069+du0p_hv18_spw
+ lu0=2.4347182e-010+dlu0p_hv18_spw                   wu0=-1.3301866e-009+dwu0p_hv18_spw
+ pu0=8.8081356e-016+dpu0p_hv18_spw                   ua=6.0268705e-010
+ lua=-3.9229678e-017       wua=5.3833599e-017        pua=3.8639696e-022
+ ub=1.0638916e-018         lub=-9.464647e-026        wub=-1.1346229e-025
+ pub=1.3228906e-030        uc=3.4144653e-011         luc=3.7084694e-017
+ wuc=-4.4838705e-017       puc=-1.2892907e-022       vsat=160000+dvsatp_hv18_spw
+ a0=1.6852174+da0p_hv18_spw                          la0=-5.9588214e-007+dla0p_hv18_spw
+ wa0=3.4561698e-006+dwa0p_hv18_spw                   pa0=-1.9353096e-012+dpa0p_hv18_spw
+ ags=0.42473009+dagsp_hv18_spw                       lags=2.8214477e-007+dlagsp_hv18_spw
+ wags=6.2960486e-007+dwagsp_hv18_spw                 pags=1.7986959e-012+dpagsp_hv18_spw
+ a1=0                      a2=1                      b0=0
+ b1=0                      keta=-0.043767909         lketa=-2.6212725e-008
+ wketa=5.7820393e-008      pketa=-1.7598027e-013     dwg=0
+ dwb=0                     pclm=0.3454944            lpclm=-4.1548017e-008
+ pdiblc1=0                 pdiblc2=0.0001            pdiblcb=0
+ drout=0.56                pvag=0                    delta=0.01
+ pscbe1=9.264e+008         pscbe2=1e-020             fprout=50
+ pdits=0                   pditsd=0                  rsh=15.2
+ rsw=169.8                 rdw=1980.2                prwg=0
+ prwb=0                    wr=1                      alpha0=1.5106e-08
+ alpha1=0.024473           beta0=30                  agidl=1e-007+dagidlp_hv18_spw
+ bgidl=9e+009+dbgidlp_hv18_spw                       cgidl=10
+ egidl=0.902               aigbacc=0.01238           bigbacc=0.006109
+ cigbacc=0.2809            nigbacc=4.05              aigbinv=0.35
+ bigbinv=0.03              cigbinv=0.006             eigbinv=1.1
+ nigbinv=1                 aigc=0.009898             bigc=0.001383
+ cigc=1.515e-005           aigsd=0.0086              bigsd=0.0004353
+ cigsd=3.925e-020          nigc=1                    poxedge=1
+ pigcd=1.672               ntox=1                    xrcrg1=12
+ xrcrg2=1                  cgso=cgsop_hv18_spw       cgdo=cgdop_hv18_spw
+ cgbo=0                    cgdl=cgdlp_hv18_spw       cgsl=cgslp_hv18_spw
+ clc=1e-007                cle=0.6                   cf=cfp_hv18_spw
+ ckappas=0.6               ckappad=0.6               acde=0.4
+ moin=6.5786               noff=2.289                voffcv=-0.0744
+ tvoff=0.0015              ltvoff=0                  wtvoff=0
+ ptvoff=0                  kt1=-0.17746395+dkt1p_hv18_spw
+ lkt1=-4.7622295e-008+dlkt1p_hv18_spw                wkt1=-6.4405853e-007+dwkt1p_hv18_spw
+ pkt1=8.459134e-014+dpkt1p_hv18_spw                  kt1l=0
+ kt2=0.0049414842          lkt2=-3.3678777e-008      wkt2=-2.6027965e-007
+ pkt2=9.1222371e-014       ute=-0.97447362           lute=-2.492881e-007
+ ua1=-6.4751048e-010       lua1=1.2217796e-015       wua1=1.3804534e-014
+ pua1=-1.2740553e-020      ub1=1.2761525e-018        lub1=-2.5469356e-024
+ wub1=-1.400794e-023       pub1=1.5617656e-029       uc1=1.349288e-011
+ luc1=-6.1072542e-017      wuc1=-1.8347173e-015      puc1=2.7600874e-021
+ prt=0                     at=22973.686+datp_hv18_spw
+ lat=-0.22435871+dlatp_hv18_spw                      wat=-0.11912254+dwatp_hv18_spw
+ pat=1.1633387e-006+dpatp_hv18_spw                   jss=1.67e-007
+ jsws=4.74e-013            jswgs=4.74e-013           njs=1.02
+ njd=1.02                  ijthsfwd=0.01             ijthdfwd=0.01
+ ijthsrev=0.01             ijthdrev=0.01             bvs=8.2
+ xjbvs=1                   xjbvd=1                   jsd=1.57e-007
+ jswd=4.56e-013            jswgd=4.56e-013           bvd=14.2
+ jtsswgs=1e-009+djtsswgsp_hv18_spw                   jtsswgd=5e-008+djtsswgdp_hv18_spw
+ njtsswg=8+dnjtsswgp_hv18_spw                        xtsswgs=0.1
+ xtsswgd=0.45              tnjtsswg=1                vtsswgs=0.6
+ vtsswgd=0.1               pbs=0.5                   cjs=cjsp_hv18_spw
+ mjs=0.24                  pbsws=0.9                 cjsws=cjswsp_hv18_spw
+ mjsws=0.02                pbswgs=0.5                cjswgs=cjswgsp_hv18_spw
+ mjswgs=0.7                pbd=0.6                   cjd=cjdp_hv18_spw
+ mjd=0.31                  pbswd=0.7                 cjswd=cjswdp_hv18_spw
+ mjswd=0.35                pbswgd=0.8                cjswgd=cjswgdp_hv18_spw
+ mjswgd=0.43               tpb=0.00155               tcj=0.0011
+ tpbsw=0.0018              tcjsw=0.0011              tpbswg=0.0018
+ tcjswg=0.00118            xtis=3                    xtid=3
+ dmcg=6.4e-08              dmci=6.4e-08              dmdg=0
+ dmcgt=0                   dwj=0                     xgw=0
+ xgl=-8.2e-09              rshg=14.1                 gbmin=1e-012
+ rbpb=50                   rbpd=50                   rbps=50
+ rbdb=50                   rbsb=50                   ngcon=1
+ lvsat=0+dlvsatp_hv18_spw  wnfactor=0+dwnfactorp_hv18_spw
+ lnfactor=0+dlnfactorp_hv18_spw                      pnfactor=0+dpnfactorp_hv18_spw
+ pvsat=0+dpvsatp_hv18_spw  wvsat=0+dwvsatp_hv18_spw  weta0=0+dweta0p_hv18_spw
+ lagidl=0+dlagidlp_hv18_spw                          wagidl=0+dwagidlp_hv18_spw
+ pagidl=0+dpagidlp_hv18_spw                          lbgidl=0+dlbgidlp_hv18_spw
+ wbgidl=0+dwbgidlp_hv18_spw                          pbgidl=0+dpbgidlp_hv18_spw
+ minr=1e-3

     8: type=p
+ lmin=8e-007-dxlp_hv18_spw lmax=1e-006-dxlp_hv18_spw wmin=1e-005-dxwp_hv18_spw
+ wmax=2e-005-dxwp_hv18_spw version=4.5               binunit=2
+ paramchk=1                mobmod=0                  capmod=2
+ igcmod=0                  igbmod=0                  diomod=1
+ rdsmod=1                  rbodymod=0                rgeomod=1
+ rgatemod=1*rgflag_hv18_snw_spw                      permod=1
+ acnqsmod=0                trnqsmod=0                tempmod=0
+ tnom=25                   toxe=toxp_hv18_spw        toxm=3.85e-009
+ dtox=3.8e-010             epsrox=3.9                wint=0
+ lint=1.221e-007           ll=0                      wl=0
+ lln=1                     wln=1                     lw=0
+ ww=0                      lwn=1                     wwn=1
+ lwl=0                     wwl=0                     llc=0
+ wlc=0                     lwc=0                     wwc=0
+ lwlc=0                    wwlc=0                    xl=1e-08+dxlp_hv18_spw
+ xw=0+dxwp_hv18_spw        dlc=ddlcp_hv18_spw        dwc=0
+ xpart=1                   toxref=3e-009             dlcig=2.5e-009
+ vth0=-0.45222156+dvthp_hv18_spw                     lvth0=5.0478146e-009+dlvthp_hv18_spw
+ wvth0=2.0962092e-007+dwvthp_hv18_spw                pvth0=-1.0615586e-013+dpvthp_hv18_spw
+ k1=0.332                  k2=-0.0043333587+dk2p_hv18_spw
+ lk2=3.6783945e-008+dlk2p_hv18_spw                   wk2=4.3794332e-007+dwk2p_hv18_spw
+ pk2=-3.4047721e-013+dpk2p_hv18_spw                  k3=-2.3465
+ k3b=1                     w0=0                      dvt0=0.75418
+ dvt1=0.034455             dvt2=0                    dvt0w=0
+ dvt1w=0                   dvt2w=0                   dsub=0.4
+ minv=-0.29809368          lminv=-1.7331412e-010     wminv=-4.5263774e-009
+ pminv=3.4662998e-015      voffl=-5e-009             dvtp0=2.5e-007
+ dvtp1=0.08                lpe0=1.4918e-007          lpeb=7.0022e-008
+ xj=8.5e-008               ngate=2.092e+020          ndep=6e+017
+ nsd=1e+020                phin=0.174                cdsc=0
+ cdscb=0                   cdscd=0                   cit=0.00024197684+dcitp_hv18_spw
+ lcit=4.9836975e-010+dlcitp_hv18_spw                 wcit=1.060022e-008+dwcitp_hv18_spw
+ pcit=-6.6561955e-015+dpcitp_hv18_spw                voff=-0.13434868+dvoffp_hv18_spw
+ lvoff=2.0921407e-008+dlvoffp_hv18_spw               wvoff=4.4220635e-007+dwvoffp_hv18_spw
+ pvoff=-2.487519e-013+dpvoffp_hv18_spw               nfactor=0.7+dnfactorp_hv18_spw
+ eta0=0.028556+deta0p_hv18_spw                       etab=-0.39999999
+ wetab=1.99999e-008        ud=0                      lud=0
+ wud=0                     pud=0                     u0=0.011684626+du0p_hv18_spw
+ lu0=1.4731999e-010+dlu0p_hv18_spw                   wu0=-4.1405793e-009+dwu0p_hv18_spw
+ pu0=3.0330123e-015+dpu0p_hv18_spw                   ua=7.5777898e-010
+ lua=-1.5799908e-016       wua=-1.3358985e-015       pua=1.4506538e-021
+ ub=8.050738e-019          lub=1.0355623e-025        wub=2.722968e-024
+ pub=-8.4924778e-031       uc=6.7494544e-011         luc=1.1545348e-017
+ wuc=-2.2722473e-016       puc=1.074215e-023         vsat=160000+dvsatp_hv18_spw
+ a0=2.058787+da0p_hv18_spw la0=-8.8196168e-007+dla0p_hv18_spw
+ wa0=3.557124e-006+dwa0p_hv18_spw                    pa0=-2.0126203e-012+dpa0p_hv18_spw
+ ags=-0.1249679+dagsp_hv18_spw                       lags=7.0310348e-007+dlagsp_hv18_spw
+ wags=-8.472218e-006+dwagsp_hv18_spw                 pags=8.7688719e-012+dpagsp_hv18_spw
+ a1=0                      a2=1                      b0=0
+ b1=0                      keta=0.053304789          lketa=-1.00551e-007
+ wketa=-9.6177434e-007     pketa=6.0482538e-013      dwg=0
+ dwb=0                     pclm=0.14979              lpclm=1.0832241e-007
+ pdiblc1=0                 pdiblc2=0.0001            pdiblcb=0
+ drout=0.56                pvag=0                    delta=0.01
+ pscbe1=9.264e+008         pscbe2=1e-020             fprout=50
+ pdits=0                   pditsd=0                  rsh=15.2
+ rsw=169.8                 rdw=1980.2                prwg=0
+ prwb=0                    wr=1                      alpha0=1.5106e-08
+ alpha1=0.024473           beta0=30                  agidl=1e-007+dagidlp_hv18_spw
+ bgidl=9e+009+dbgidlp_hv18_spw                       cgidl=10
+ egidl=0.902               aigbacc=0.01238           bigbacc=0.006109
+ cigbacc=0.2809            nigbacc=4.05              aigbinv=0.35
+ bigbinv=0.03              cigbinv=0.006             eigbinv=1.1
+ nigbinv=1                 aigc=0.009898             bigc=0.001383
+ cigc=1.515e-005           aigsd=0.0086              bigsd=0.0004353
+ cigsd=3.925e-020          nigc=1                    poxedge=1
+ pigcd=1.672               ntox=1                    xrcrg1=12
+ xrcrg2=1                  cgso=cgsop_hv18_spw       cgdo=cgdop_hv18_spw
+ cgbo=0                    cgdl=cgdlp_hv18_spw       cgsl=cgslp_hv18_spw
+ clc=1e-007                cle=0.6                   cf=cfp_hv18_spw
+ ckappas=0.6               ckappad=0.6               acde=0.4
+ moin=6.5786               noff=2.289                voffcv=-0.0744
+ tvoff=0.0015              ltvoff=0                  wtvoff=0
+ ptvoff=0                  kt1=-0.033926568+dkt1p_hv18_spw
+ lkt1=-1.5754322e-007+dlkt1p_hv18_spw                wkt1=-2.7436003e-006+dwkt1p_hv18_spw
+ pkt1=1.6924204e-012+dpkt1p_hv18_spw                 kt1l=0
+ kt2=0.084046174           lkt2=-9.4257149e-008      wkt2=-1.8932067e-006
+ pkt2=1.3417179e-012       ute=-1.3                  ua1=-1.9603307e-009
+ lua1=2.2271373e-015       wua1=3.6853766e-014       pua1=-3.0391656e-020
+ ub1=7.0391622e-019        lub1=-2.108717e-024       wub1=-3.5882463e-023
+ pub1=3.2369166e-029       uc1=-3.1936006e-010       luc1=1.9382624e-016
+ wuc1=5.7857257e-015       puc1=-3.0756478e-021      prt=0
+ at=-524606.75+datp_hv18_spw                         lat=0.19497839+dlatp_hv18_spw
+ wat=6.4921675+dwatp_hv18_spw                        pat=-3.8995873e-006+dpatp_hv18_spw
+ jss=1.67e-007             jsws=4.74e-013            jswgs=4.74e-013
+ njs=1.02                  njd=1.02                  ijthsfwd=0.01
+ ijthdfwd=0.01             ijthsrev=0.01             ijthdrev=0.01
+ bvs=8.2                   xjbvs=1                   xjbvd=1
+ jsd=1.57e-007             jswd=4.56e-013            jswgd=4.56e-013
+ bvd=14.2                  jtsswgs=1e-009+djtsswgsp_hv18_spw
+ jtsswgd=5e-008+djtsswgdp_hv18_spw                   njtsswg=8+dnjtsswgp_hv18_spw
+ xtsswgs=0.1               xtsswgd=0.45              tnjtsswg=1
+ vtsswgs=0.6               vtsswgd=0.1               pbs=0.5
+ cjs=cjsp_hv18_spw         mjs=0.24                  pbsws=0.9
+ cjsws=cjswsp_hv18_spw     mjsws=0.02                pbswgs=0.5
+ cjswgs=cjswgsp_hv18_spw   mjswgs=0.7                pbd=0.6
+ cjd=cjdp_hv18_spw         mjd=0.31                  pbswd=0.7
+ cjswd=cjswdp_hv18_spw     mjswd=0.35                pbswgd=0.8
+ cjswgd=cjswgdp_hv18_spw   mjswgd=0.43               tpb=0.00155
+ tcj=0.0011                tpbsw=0.0018              tcjsw=0.0011
+ tpbswg=0.0018             tcjswg=0.00118            xtis=3
+ xtid=3                    dmcg=6.4e-08              dmci=6.4e-08
+ dmdg=0                    dmcgt=0                   dwj=0
+ xgw=0                     xgl=-8.2e-09              rshg=14.1
+ gbmin=1e-012              rbpb=50                   rbpd=50
+ rbps=50                   rbdb=50                   rbsb=50
+ ngcon=1                   lvsat=0+dlvsatp_hv18_spw  wnfactor=0+dwnfactorp_hv18_spw
+ lnfactor=0+dlnfactorp_hv18_spw                      pnfactor=0+dpnfactorp_hv18_spw
+ pvsat=0+dpvsatp_hv18_spw  wvsat=0+dwvsatp_hv18_spw  weta0=0+dweta0p_hv18_spw
+ lagidl=0+dlagidlp_hv18_spw                          wagidl=0+dwagidlp_hv18_spw
+ pagidl=0+dpagidlp_hv18_spw                          lbgidl=0+dlbgidlp_hv18_spw
+ wbgidl=0+dwbgidlp_hv18_spw                          pbgidl=0+dpbgidlp_hv18_spw
+ minr=1e-3

     9: type=p
+ lmin=7e-007-dxlp_hv18_spw lmax=8e-007-dxlp_hv18_spw wmin=1e-005-dxwp_hv18_spw
+ wmax=2e-005-dxwp_hv18_spw version=4.5               binunit=2
+ paramchk=1                mobmod=0                  capmod=2
+ igcmod=0                  igbmod=0                  diomod=1
+ rdsmod=1                  rbodymod=0                rgeomod=1
+ rgatemod=1*rgflag_hv18_snw_spw                      permod=1
+ acnqsmod=0                trnqsmod=0                tempmod=0
+ tnom=25                   toxe=toxp_hv18_spw        toxm=3.85e-009
+ dtox=3.8e-010             epsrox=3.9                wint=0
+ lint=1.221e-007           ll=0                      wl=0
+ lln=1                     wln=1                     lw=0
+ ww=0                      lwn=1                     wwn=1
+ lwl=0                     wwl=0                     llc=0
+ wlc=0                     lwc=0                     wwc=0
+ lwlc=0                    wwlc=0                    xl=1e-08+dxlp_hv18_spw
+ xw=0+dxwp_hv18_spw        dlc=ddlcp_hv18_spw        dwc=0
+ xpart=1                   toxref=3e-009             dlcig=2.5e-009
+ vth0=-0.40435916+dvthp_hv18_spw                     lvth0=-2.2032735e-008+dlvthp_hv18_spw
+ wvth0=-9.6176925e-007+dwvthp_hv18_spw               pvth0=5.5661669e-013+dpvthp_hv18_spw
+ k1=0.332                  k2=0.06788477+dk2p_hv18_spw
+ lk2=-4.0770722e-009+dlk2p_hv18_spw                  wk2=-2.8902548e-007+dwk2p_hv18_spw
+ pk2=7.0841736e-014+dpk2p_hv18_spw                   k3=-2.3465
+ k3b=1                     w0=0                      dvt0=0.75418
+ dvt1=0.034455             dvt2=0                    dvt0w=0
+ dvt1w=0                   dvt2w=0                   dsub=0.4
+ minv=-0.29877264          lminv=2.108376e-010       wminv=9.0527547e-009
+ pminv=-4.2167732e-015     voffl=-5e-009             dvtp0=2.5e-007
+ dvtp1=0.08                lpe0=1.4918e-007          lpeb=7.0022e-008
+ xj=8.5e-008               ngate=2.092e+020          ndep=6e+017
+ nsd=1e+020                phin=0.174                cdsc=0
+ cdscb=0                   cdscd=0                   cit=0.0027102466+dcitp_hv18_spw
+ lcit=-8.9817727e-010+dlcitp_hv18_spw                wcit=-2.6894794e-008+dwcitp_hv18_spw
+ pcit=1.4558483e-014+dpcitp_hv18_spw                 voff=-0.054755986+dvoffp_hv18_spw
+ lvoff=-2.4112141e-008+dlvoffp_hv18_spw              wvoff=-1.0588112e-006+dwvoffp_hv18_spw
+ pvoff=6.0052384e-013+dpvoffp_hv18_spw               nfactor=0.7+dnfactorp_hv18_spw
+ eta0=0.028556+deta0p_hv18_spw                       etab=-0.39999999
+ wetab=1.99999e-008        ud=0                      lud=0
+ wud=0                     pud=0                     u0=0.013463509+du0p_hv18_spw
+ lu0=-8.5917214e-010+dlu0p_hv18_spw                  wu0=-1.6294092e-008+dwu0p_hv18_spw
+ pu0=9.9094696e-015+dpu0p_hv18_spw                   ua=1.2517121e-009
+ lua=-4.3746644e-016       wua=-3.7169397e-015       pua=2.7978469e-021
+ ub=1.0104581e-018         lub=-1.2650193e-026       wub=-3.1751488e-024
+ pub=2.4879067e-030        uc=1.9001184e-010         luc=-5.777494e-017
+ wuc=-1.7101573e-015       puc=8.4978537e-022        vsat=160000+dvsatp_hv18_spw
+ a0=1.8944656+da0p_hv18_spw                          la0=-7.8898865e-007+dla0p_hv18_spw
+ wa0=-9.2573078e-006+dwa0p_hv18_spw                  pa0=5.2377852e-012+dpa0p_hv18_spw
+ ags=-2.5886656+dagsp_hv18_spw                       lags=2.0970636e-006+dlagsp_hv18_spw
+ wags=7.277477e-006+dwagsp_hv18_spw                  pags=-1.4230555e-013+dpagsp_hv18_spw
+ a1=0                      a2=1                      b0=0
+ b1=0                      keta=-0.093946507         lketa=-1.7236214e-008
+ wketa=3.4568787e-007      pketa=-1.3493674e-013     dwg=0
+ dwb=0                     pclm=0.34124              pdiblc1=0
+ pdiblc2=0.0001            pdiblcb=0                 drout=0.56
+ pvag=0                    delta=0.01                pscbe1=9.264e+008
+ pscbe2=1e-020             fprout=50                 pdits=0
+ pditsd=0                  rsh=15.2                  rsw=169.8
+ rdw=1980.2                prwg=0                    prwb=0
+ wr=1                      alpha0=1.5106e-08         alpha1=0.024473
+ beta0=30                  agidl=1e-007+dagidlp_hv18_spw
+ bgidl=9e+009+dbgidlp_hv18_spw                       cgidl=10
+ egidl=0.902               aigbacc=0.01238           bigbacc=0.006109
+ cigbacc=0.2809            nigbacc=4.05              aigbinv=0.35
+ bigbinv=0.03              cigbinv=0.006             eigbinv=1.1
+ nigbinv=1                 aigc=0.009898             bigc=0.001383
+ cigc=1.515e-005           aigsd=0.0086              bigsd=0.0004353
+ cigsd=3.925e-020          nigc=1                    poxedge=1
+ pigcd=1.672               ntox=1                    xrcrg1=12
+ xrcrg2=1                  cgso=cgsop_hv18_spw       cgdo=cgdop_hv18_spw
+ cgbo=0                    cgdl=cgdlp_hv18_spw       cgsl=cgslp_hv18_spw
+ clc=1e-007                cle=0.6                   cf=cfp_hv18_spw
+ ckappas=0.6               ckappad=0.6               acde=0.4
+ moin=6.5786               noff=2.289                voffcv=-0.0744
+ tvoff=0.0015              ltvoff=0                  wtvoff=0
+ ptvoff=0                  kt1=-0.44158197+dkt1p_hv18_spw
+ lkt1=7.3108202e-008+dlkt1p_hv18_spw                 wkt1=1.9021121e-006+dwkt1p_hv18_spw
+ pkt1=-9.3612364e-013+dpkt1p_hv18_spw                kt1l=0
+ kt2=-0.42230642           lkt2=1.9223715e-007       wkt2=4.6719196e-006
+ pkt2=-2.3728305e-012      ute=-1.3                  ua1=1.4533036e-008
+ lua1=-7.1048098e-015      wua1=-1.7547236e-013      pua1=8.9742466e-020
+ ub1=-2.3372611e-017       lub1=1.1513782e-023       wub1=2.712285e-022
+ pub1=-1.4139422e-028      uc1=5.1101309e-011        luc1=-1.5780802e-017
+ wuc1=-1.5490725e-015      puc1=1.074381e-021        prt=0
+ at=146058.82+datp_hv18_spw                          lat=-0.18448419+dlatp_hv18_spw
+ wat=-2.2631877+dwatp_hv18_spw                       pat=1.0541928e-006+dpatp_hv18_spw
+ jss=1.67e-007             jsws=4.74e-013            jswgs=4.74e-013
+ njs=1.02                  njd=1.02                  ijthsfwd=0.01
+ ijthdfwd=0.01             ijthsrev=0.01             ijthdrev=0.01
+ bvs=8.2                   xjbvs=1                   xjbvd=1
+ jsd=1.57e-007             jswd=4.56e-013            jswgd=4.56e-013
+ bvd=14.2                  jtsswgs=1e-009+djtsswgsp_hv18_spw
+ jtsswgd=5e-008+djtsswgdp_hv18_spw                   njtsswg=8+dnjtsswgp_hv18_spw
+ xtsswgs=0.1               xtsswgd=0.45              tnjtsswg=1
+ vtsswgs=0.6               vtsswgd=0.1               pbs=0.5
+ cjs=cjsp_hv18_spw         mjs=0.24                  pbsws=0.9
+ cjsws=cjswsp_hv18_spw     mjsws=0.02                pbswgs=0.5
+ cjswgs=cjswgsp_hv18_spw   mjswgs=0.7                pbd=0.6
+ cjd=cjdp_hv18_spw         mjd=0.31                  pbswd=0.7
+ cjswd=cjswdp_hv18_spw     mjswd=0.35                pbswgd=0.8
+ cjswgd=cjswgdp_hv18_spw   mjswgd=0.43               tpb=0.00155
+ tcj=0.0011                tpbsw=0.0018              tcjsw=0.0011
+ tpbswg=0.0018             tcjswg=0.00118            xtis=3
+ xtid=3                    dmcg=6.4e-08              dmci=6.4e-08
+ dmdg=0                    dmcgt=0                   dwj=0
+ xgw=0                     xgl=-8.2e-09              rshg=14.1
+ gbmin=1e-012              rbpb=50                   rbpd=50
+ rbps=50                   rbdb=50                   rbsb=50
+ ngcon=1                   lvsat=0+dlvsatp_hv18_spw  wnfactor=0+dwnfactorp_hv18_spw
+ lnfactor=0+dlnfactorp_hv18_spw                      pnfactor=0+dpnfactorp_hv18_spw
+ pvsat=0+dpvsatp_hv18_spw  wvsat=0+dwvsatp_hv18_spw  weta0=0+dweta0p_hv18_spw
+ lagidl=0+dlagidlp_hv18_spw                          wagidl=0+dwagidlp_hv18_spw
+ pagidl=0+dpagidlp_hv18_spw                          lbgidl=0+dlbgidlp_hv18_spw
+ wbgidl=0+dwbgidlp_hv18_spw                          pbgidl=0+dpbgidlp_hv18_spw
+ minr=1e-3

     10: type=p
+ lmin=0.594e-06            lmax=7e-007-dxlp_hv18_spw wmin=1e-005-dxwp_hv18_spw
+ wmax=2e-005-dxwp_hv18_spw version=4.5               binunit=2
+ paramchk=1                mobmod=0                  capmod=2
+ igcmod=0                  igbmod=0                  diomod=1
+ rdsmod=1                  rbodymod=0                rgeomod=1
+ rgatemod=1*rgflag_hv18_snw_spw                      permod=1
+ acnqsmod=0                trnqsmod=0                tempmod=0
+ tnom=25                   toxe=toxp_hv18_spw        toxm=3.85e-009
+ dtox=3.8e-010             epsrox=3.9                wint=0
+ lint=1.221e-007           ll=0                      wl=0
+ lln=1                     wln=1                     lw=0
+ ww=0                      lwn=1                     wwn=1
+ lwl=0                     wwl=0                     llc=0
+ wlc=0                     lwc=0                     wwc=0
+ lwlc=0                    wwlc=0                    xl=1e-08+dxlp_hv18_spw
+ xw=0+dxwp_hv18_spw        dlc=ddlcp_hv18_spw        dwc=0
+ xpart=1                   toxref=3e-009             dlcig=2.5e-009
+ vth0=-0.50015892+dvthp_hv18_spw                     lvth0=2.2590796e-08+dlvthp_hv18_spw
+ wvth0=8.0299303e-07+dwvthp_hv18_spw                 pvth0=-2.6540959e-13+dpvthp_hv18_spw
+ k1=0.332                  k2=0.11486504+dk2p_hv18_spw
+ lk2=-2.5960482e-008+dlk2p_hv18_spw                  wk2=-4.7947265e-007+dwk2p_hv18_spw
+ pk2=1.5955203e-013+dpk2p_hv18_spw                   k3=-2.3465
+ k3b=1                     w0=0                      dvt0=0.75418
+ dvt1=0.034455             dvt2=0                    dvt0w=0
+ dvt1w=0                   dvt2w=0                   dsub=0.4
+ minv=-0.2953936           lminv=-1.3631171e-009     voffl=-5e-009
+ dvtp0=2.5e-007            dvtp1=0.08                lpe0=1.4918e-007
+ lpeb=7.0022e-008          xj=8.5e-008               ngate=2.092e+020
+ ndep=6e+017               nsd=1e+020                phin=0.174
+ cdsc=0                    cdscb=0                   cdscd=0
+ cit=-0.00073936188+dcitp_hv18_spw                   lcit=7.0865035e-010+dlcitp_hv18_spw
+ wcit=2.1142901e-008+dwcitp_hv18_spw                 pcit=-7.8174751e-015+dpcitp_hv18_spw
+ voff=-0.16569287+dvoffp_hv18_spw                    lvoff=2.756226e-008+dlvoffp_hv18_spw
+ wvoff=9.3560953e-007+dwvoffp_hv18_spw               pvoff=-3.2847735e-013+dpvoffp_hv18_spw
+ nfactor=0.7+dnfactorp_hv18_spw                      eta0=0.028556+deta0p_hv18_spw
+ etab=-0.39999999          wetab=1.99999e-008        ud=0
+ lud=0                     wud=0                     pud=0
+ u0=0.010872764+du0p_hv18_spw                        lu0=3.4759705e-010+dlu0p_hv18_spw
+ wu0=1.0247562e-008+dwu0p_hv18_spw                   pu0=-2.4536326e-015+dpu0p_hv18_spw
+ ua=7.3273344e-010         lua=-1.9572618e-016       wua=1.1395108e-014
+ pua=-4.241345e-021        ub=9.1634526e-019         lub=3.1187559e-026
+ wub=-1.8106506e-023       pub=9.442933e-030         uc=1.3832194e-010
+ luc=-3.3697784e-017       wuc=-6.073006e-016        puc=3.3607474e-022
+ vsat=160000+dvsatp_hv18_spw                         a0=0.56872706+da0p_hv18_spw-0.5487*ss_flag_hv18_snw_spw+0.3658*ff_flag_hv18_snw_spw
+ la0=-1.7145964e-007+dla0p_hv18_spw+2.55584e-07*ss_flag_hv18_snw_spw-1.7039e-07*ff_flag_hv18_snw_spw
+ wa0=-5.3746153e-006+dwa0p_hv18_spw+1.0974e-05*ss_flag_hv18_snw_spw-7.316e-06*ff_flag_hv18_snw_spw
+ pa0=3.429227e-012+dpa0p_hv18_spw-5.11169e-12*ss_flag_hv18_snw_spw+3.40779e-12*ff_flag_hv18_snw_spw
+ ags=-4.3878652+dagsp_hv18_spw-1.4632*ff_flag_hv18_snw_spw+3.658*ss_flag_hv18_snw_spw
+ lags=2.9351308e-006+dlagsp_hv18_spw+6.81559e-07*ff_flag_hv18_snw_spw-1.7039e-06*ss_flag_hv18_snw_spw
+ wags=2.2715974e-005+dwagsp_hv18_spw+2.9264e-05*ff_flag_hv18_snw_spw-7.316e-05*ss_flag_hv18_snw_spw
+ pags=-7.3335573e-012+dpagsp_hv18_spw-1.36312e-11*ff_flag_hv18_snw_spw+3.40779e-11*ss_flag_hv18_snw_spw
+ a1=0                      a2=1                      b0=0
+ b1=0                      keta=-0.1717727           lketa=1.9015227e-008
+ wketa=1.1585154e-006      pketa=-5.1355181e-013     dwg=0
+ dwb=0                     pclm=0.56525365           lpclm=-1.0434556e-007
+ wpclm=-4.3895773e-006     ppclm=2.0446651e-012      pdiblc1=0
+ pdiblc2=0.0001            pdiblcb=0                 drout=0.56
+ pvag=0                    delta=0.01                pscbe1=9.264e+008
+ pscbe2=1e-020             fprout=50                 pdits=0
+ pditsd=0                  rsh=15.2                  rsw=169.8
+ rdw=1980.2                prwg=0                    prwb=0
+ wr=1                      alpha0=1.5106e-08         alpha1=0.024473
+ beta0=30                  agidl=1e-007+dagidlp_hv18_spw
+ bgidl=9e+009+dbgidlp_hv18_spw                       cgidl=10
+ egidl=0.902               aigbacc=0.01238           bigbacc=0.006109
+ cigbacc=0.2809            nigbacc=4.05              aigbinv=0.35
+ bigbinv=0.03              cigbinv=0.006             eigbinv=1.1
+ nigbinv=1                 aigc=0.009898             bigc=0.001383
+ cigc=1.515e-005           aigsd=0.0086              bigsd=0.0004353
+ cigsd=3.925e-020          nigc=1                    poxedge=1
+ pigcd=1.672               ntox=1                    xrcrg1=12
+ xrcrg2=1                  cgso=cgsop_hv18_spw       cgdo=cgdop_hv18_spw
+ cgbo=0                    cgdl=cgdlp_hv18_spw       cgsl=cgslp_hv18_spw
+ clc=1e-007                cle=0.6                   cf=cfp_hv18_spw
+ ckappas=0.6               ckappad=0.6               acde=0.4
+ moin=6.5786               noff=2.289                voffcv=-0.0744
+ tvoff=0.0015              ltvoff=0                  wtvoff=0
+ ptvoff=0                  kt1=-0.22171227+dkt1p_hv18_spw
+ lkt1=-2.9307105e-008+dlkt1p_hv18_spw                wkt1=2.6551467e-007+dwkt1p_hv18_spw
+ pkt1=-1.7379656e-013+dpkt1p_hv18_spw                kt1l=0
+ kt2=0.12097177            lkt2=-6.0821831e-008      wkt2=-2.2728231e-006
+ pkt2=8.6203062e-013       ute=-1.3                  ua1=-4.1710873e-009
+ lua1=1.607571e-015        wua1=4.8033433e-014       pua1=-1.4366532e-020
+ ub1=6.4137423e-018        lub1=-2.3607013e-024      wub1=-9.4171297e-023
+ pub1=2.8809009e-029       uc1=-1.9577517e-010       luc1=9.9214261e-017
+ wuc1=1.6355909e-015       puc1=-4.0903519e-022      prt=0
+ at=-249999.95+datp_hv18_spw                         lat=-1.7038794e-008+dlatp_hv18_spw
+ wat=-9.3159542e-007+dwatp_hv18_spw                  pat=3.4077758e-013+dpatp_hv18_spw
+ jss=1.67e-007             jsws=4.74e-013            jswgs=4.74e-013
+ njs=1.02                  njd=1.02                  ijthsfwd=0.01
+ ijthdfwd=0.01             ijthsrev=0.01             ijthdrev=0.01
+ bvs=8.2                   xjbvs=1                   xjbvd=1
+ jsd=1.57e-007             jswd=4.56e-013            jswgd=4.56e-013
+ bvd=14.2                  jtsswgs=1e-009+djtsswgsp_hv18_spw
+ jtsswgd=5e-008+djtsswgdp_hv18_spw                   njtsswg=8+dnjtsswgp_hv18_spw
+ xtsswgs=0.1               xtsswgd=0.45              tnjtsswg=1
+ vtsswgs=0.6               vtsswgd=0.1               pbs=0.5
+ cjs=cjsp_hv18_spw         mjs=0.24                  pbsws=0.9
+ cjsws=cjswsp_hv18_spw     mjsws=0.02                pbswgs=0.5
+ cjswgs=cjswgsp_hv18_spw   mjswgs=0.7                pbd=0.6
+ cjd=cjdp_hv18_spw         mjd=0.31                  pbswd=0.7
+ cjswd=cjswdp_hv18_spw     mjswd=0.35                pbswgd=0.8
+ cjswgd=cjswgdp_hv18_spw   mjswgd=0.43               tpb=0.00155
+ tcj=0.0011                tpbsw=0.0018              tcjsw=0.0011
+ tpbswg=0.0018             tcjswg=0.00118            xtis=3
+ xtid=3                    dmcg=6.4e-08              dmci=6.4e-08
+ dmdg=0                    dmcgt=0                   dwj=0
+ xgw=0                     xgl=-8.2e-09              rshg=14.1
+ gbmin=1e-012              rbpb=50                   rbpd=50
+ rbps=50                   rbdb=50                   rbsb=50
+ ngcon=1                   lvsat=0+dlvsatp_hv18_spw  wnfactor=0+dwnfactorp_hv18_spw
+ lnfactor=0+dlnfactorp_hv18_spw                      pnfactor=0+dpnfactorp_hv18_spw
+ pvsat=0+dpvsatp_hv18_spw  wvsat=0+dwvsatp_hv18_spw  weta0=0+dweta0p_hv18_spw
+ lagidl=0+dlagidlp_hv18_spw                          wagidl=0+dwagidlp_hv18_spw
+ pagidl=0+dpagidlp_hv18_spw                          lbgidl=0+dlbgidlp_hv18_spw
+ wbgidl=0+dwbgidlp_hv18_spw                          pbgidl=0+dpbgidlp_hv18_spw
+ minr=1e-3

     11: type=p
+ lmin=1e-005-dxlp_hv18_spw lmax=900.001e-6           wmin=1e-006-dxwp_hv18_spw
+ wmax=1e-005-dxwp_hv18_spw version=4.5               binunit=2
+ paramchk=1                mobmod=0                  capmod=2
+ igcmod=0                  igbmod=0                  diomod=1
+ rdsmod=1                  rbodymod=0                rgeomod=1
+ rgatemod=1*rgflag_hv18_snw_spw                      permod=1
+ acnqsmod=0                trnqsmod=0                tempmod=0
+ tnom=25                   toxe=toxp_hv18_spw        toxm=3.85e-009
+ dtox=3.8e-010             epsrox=3.9                wint=0
+ lint=1.221e-007           ll=0                      wl=0
+ lln=1                     wln=1                     lw=0
+ ww=0                      lwn=1                     wwn=1
+ lwl=0                     wwl=0                     llc=0
+ wlc=0                     lwc=0                     wwc=0
+ lwlc=0                    wwlc=0                    xl=1e-08+dxlp_hv18_spw
+ xw=0+dxwp_hv18_spw        dlc=ddlcp_hv18_spw        dwc=0
+ xpart=1                   toxref=3e-009             dlcig=2.5e-009
+ vth0=-0.44593779+dvthp_hv18_spw                     wvth0=-5.6222222e-009+dwvthp_hv18_spw
+ k1=0.332                  k2=0.031946545+dk2p_hv18_spw
+ wk2=-1.7055522e-009+dwk2p_hv18_spw                  k3=-2.3465
+ k3b=1                     w0=0                      dvt0=0.75418
+ dvt1=0.034455             dvt2=0                    dvt0w=0
+ dvt1w=0                   dvt2w=0                   dsub=0.4
+ minv=-0.29832             voffl=-5e-009             dvtp0=2.5e-007
+ dvtp1=0.08                lpe0=1.4918e-007          lpeb=7.0022e-008
+ xj=8.5e-008               ngate=2.092e+020          ndep=6e+017
+ nsd=1e+020                phin=0.174                cdsc=0
+ cdscb=0                   cdscd=0                   cit=0.000958381+dcitp_hv18_spw
+ wcit=-4.1113333e-013+dwcitp_hv18_spw                voff=-0.1187589+dvoffp_hv18_spw
+ wvoff=5.5889e-009+dwvoffp_hv18_spw                  nfactor=0.7+dnfactorp_hv18_spw
+ eta0=0.028556+deta0p_hv18_spw                       etab=-0.398
+ ud=0                      lud=0                     wud=0
+ pud=0                     u0=0.011390889+du0p_hv18_spw
+ wu0=6.9111111e-010+dwu0p_hv18_spw                   ua=6.2591e-010
+ wua=-1.7900003e-016       ub=1.0433332e-018         wub=1.3066689e-025
+ uc=3.2935504e-011         wuc=-7.9755211e-018       vsat=160000+dvsatp_hv18_spw
+ a0=1.922223+da0p_hv18_spw wa0=2.7777778e-007+dwa0p_hv18_spw
+ ags=0.53454615+dagsp_hv18_spw                       wags=4.5335778e-009+dwagsp_hv18_spw
+ a1=0                      a2=1                      b0=0
+ b1=0                      keta=-0.042443631         wketa=-2.8333222e-010
+ dwg=0                     dwb=0                     pclm=0.34124
+ pdiblc1=0                 pdiblc2=0.0001            pdiblcb=0
+ drout=0.56                pvag=0                    delta=0.01
+ pscbe1=9.264e+008         pscbe2=1e-020             fprout=50
+ pdits=0                   pditsd=0                  rsh=15.2
+ rsw=169.8                 rdw=1980.2                prwg=0
+ prwb=0                    wr=1                      alpha0=1.5106e-08
+ alpha1=0.024473           beta0=30                  agidl=1e-007+dagidlp_hv18_spw
+ bgidl=9e+009+dbgidlp_hv18_spw                       cgidl=10
+ egidl=0.902               aigbacc=0.01238           bigbacc=0.006109
+ cigbacc=0.2809            nigbacc=4.05              aigbinv=0.35
+ bigbinv=0.03              cigbinv=0.006             eigbinv=1.1
+ nigbinv=1                 aigc=0.009898             bigc=0.001383
+ cigc=1.515e-005           aigsd=0.0086              bigsd=0.0004353
+ cigsd=3.925e-020          nigc=1                    poxedge=1
+ pigcd=1.672               ntox=1                    xrcrg1=12
+ xrcrg2=1                  cgso=cgsop_hv18_spw       cgdo=cgdop_hv18_spw
+ cgbo=0                    cgdl=cgdlp_hv18_spw       cgsl=cgslp_hv18_spw
+ clc=1e-007                cle=0.6                   cf=cfp_hv18_spw
+ ckappas=0.6               ckappad=0.6               acde=0.4
+ moin=6.5786               noff=2.289                voffcv=-0.0744
+ tvoff=0.0015              ltvoff=0                  wtvoff=0
+ ptvoff=0                  kt1=-0.24957778+dkt1p_hv18_spw
+ wkt1=3.6977778e-008+dwkt1p_hv18_spw                 kt1l=0
+ kt2=-0.022888778          wkt2=-7.1222222e-009      ute=-1
+ ua1=7.1894111e-010        wua1=8.6488889e-017       ub1=-1.9779889e-019
+ wub1=-2.7721111e-025      uc1=-1.7114211e-010       wuc1=2.3172111e-016
+ prt=0                     at=-0.0005142076+datp_hv18_spw
+ wat=6.3903989e-011+dwatp_hv18_spw                   jss=1.67e-007
+ jsws=4.74e-013            jswgs=4.74e-013           njs=1.02
+ njd=1.02                  ijthsfwd=0.01             ijthdfwd=0.01
+ ijthsrev=0.01             ijthdrev=0.01             bvs=8.2
+ xjbvs=1                   xjbvd=1                   jsd=1.57e-007
+ jswd=4.56e-013            jswgd=4.56e-013           bvd=14.2
+ jtsswgs=1e-009+djtsswgsp_hv18_spw                   jtsswgd=5e-008+djtsswgdp_hv18_spw
+ njtsswg=8+dnjtsswgp_hv18_spw                        xtsswgs=0.1
+ xtsswgd=0.45              tnjtsswg=1                vtsswgs=0.6
+ vtsswgd=0.1               pbs=0.5                   cjs=cjsp_hv18_spw
+ mjs=0.24                  pbsws=0.9                 cjsws=cjswsp_hv18_spw
+ mjsws=0.02                pbswgs=0.5                cjswgs=cjswgsp_hv18_spw
+ mjswgs=0.7                pbd=0.6                   cjd=cjdp_hv18_spw
+ mjd=0.31                  pbswd=0.7                 cjswd=cjswdp_hv18_spw
+ mjswd=0.35                pbswgd=0.8                cjswgd=cjswgdp_hv18_spw
+ mjswgd=0.43               tpb=0.00155               tcj=0.0011
+ tpbsw=0.0018              tcjsw=0.0011              tpbswg=0.0018
+ tcjswg=0.00118            xtis=3                    xtid=3
+ dmcg=6.4e-08              dmci=6.4e-08              dmdg=0
+ dmcgt=0                   dwj=0                     xgw=0
+ xgl=-8.2e-09              rshg=14.1                 gbmin=1e-012
+ rbpb=50                   rbpd=50                   rbps=50
+ rbdb=50                   rbsb=50                   ngcon=1
+ lvth0=0+dlvthp_hv18_spw   pvth0=0+dpvthp_hv18_spw   lu0=0+dlu0p_hv18_spw
+ pu0=0+dpu0p_hv18_spw      la0=0+dla0p_hv18_spw      pa0=0+dpa0p_hv18_spw
+ lags=0+dlagsp_hv18_spw    pags=0+dpagsp_hv18_spw    lvsat=0+dlvsatp_hv18_spw
+ wnfactor=0+dwnfactorp_hv18_spw                      lnfactor=0+dlnfactorp_hv18_spw
+ pnfactor=0+dpnfactorp_hv18_spw                      pvsat=0+dpvsatp_hv18_spw
+ wvsat=0+dwvsatp_hv18_spw  lk2=0+dlk2p_hv18_spw      pk2=0+dpk2p_hv18_spw
+ weta0=0+dweta0p_hv18_spw  lcit=0+dlcitp_hv18_spw    pcit=0+dpcitp_hv18_spw
+ lvoff=0+dlvoffp_hv18_spw  pvoff=0+dpvoffp_hv18_spw  lkt1=0+dlkt1p_hv18_spw
+ pkt1=0+dpkt1p_hv18_spw    lat=0+dlatp_hv18_spw      pat=0+dpatp_hv18_spw
+ lagidl=0+dlagidlp_hv18_spw                          wagidl=0+dwagidlp_hv18_spw
+ pagidl=0+dpagidlp_hv18_spw                          lbgidl=0+dlbgidlp_hv18_spw
+ wbgidl=0+dwbgidlp_hv18_spw                          pbgidl=0+dpbgidlp_hv18_spw
+ minr=1e-3

     12: type=p
+ lmin=1e-006-dxlp_hv18_spw lmax=1e-005-dxlp_hv18_spw wmin=1e-006-dxwp_hv18_spw
+ wmax=1e-005-dxwp_hv18_spw version=4.5               binunit=2
+ paramchk=1                mobmod=0                  capmod=2
+ igcmod=0                  igbmod=0                  diomod=1
+ rdsmod=1                  rbodymod=0                rgeomod=1
+ rgatemod=1*rgflag_hv18_snw_spw                      permod=1
+ acnqsmod=0                trnqsmod=0                tempmod=0
+ tnom=25                   toxe=toxp_hv18_spw        toxm=3.85e-009
+ dtox=3.8e-010             epsrox=3.9                wint=0
+ lint=1.221e-007           ll=0                      wl=0
+ lln=1                     wln=1                     lw=0
+ ww=0                      lwn=1                     wwn=1
+ lwl=0                     wwl=0                     llc=0
+ wlc=0                     lwc=0                     wwc=0
+ lwlc=0                    wwlc=0                    xl=1e-08+dxlp_hv18_spw
+ xw=0+dxwp_hv18_spw        dlc=ddlcp_hv18_spw        dwc=0
+ xpart=1                   toxref=3e-009             dlcig=2.5e-009
+ vth0=-0.44661178+dvthp_hv18_spw                     lvth0=6.5821375e-009+dlvthp_hv18_spw
+ wvth0=-5.6638208e-009+dwvthp_hv18_spw               pvth0=4.0624728e-016+dpvthp_hv18_spw
+ k1=0.332                  k2=0.030960914+dk2p_hv18_spw
+ lk2=9.6255763e-009+dlk2p_hv18_spw                   wk2=-1.4284489e-009+dwk2p_hv18_spw
+ pk2=-2.7061636e-015+dpk2p_hv18_spw                  k3=-2.3465
+ k3b=1                     w0=0                      dvt0=0.75418
+ dvt1=0.034455             dvt2=0                    dvt0w=0
+ dvt1w=0                   dvt2w=0                   dsub=0.4
+ minv=-0.29831924          lminv=-7.3863142e-012     wminv=-7.5633728e-012
+ pminv=7.3863142e-017      voffl=-5e-009             dvtp0=2.5e-007
+ dvtp1=0.08                lpe0=1.4918e-007          lpeb=7.0022e-008
+ xj=8.5e-008               ngate=2.092e+020          ndep=6e+017
+ nsd=1e+020                phin=0.174                cdsc=0
+ cdscb=0                   cdscd=0                   cit=0.00094792208+dcitp_hv18_spw
+ lcit=1.0214081e-010+dlcitp_hv18_spw                 wcit=-2.4031385e-012+dwcitp_hv18_spw
+ pcit=1.9453724e-017+dpcitp_hv18_spw                 voff=-0.12080224+dvoffp_hv18_spw
+ lvoff=1.9955067e-008+dlvoffp_hv18_spw               wvoff=6.5295016e-009+dwvoffp_hv18_spw
+ pvoff=-9.1858207e-015+dpvoffp_hv18_spw              nfactor=0.7+dnfactorp_hv18_spw
+ eta0=0.028556+deta0p_hv18_spw                       etab=-0.398
+ ud=0                      lud=0                     wud=0
+ pud=0                     u0=0.011358461+du0p_hv18_spw
+ lu0=3.1668822e-010+dlu0p_hv18_spw                   wu0=6.7588982e-010+dwu0p_hv18_spw
+ pu0=1.4864957e-016+dpu0p_hv18_spw                   ua=6.2622133e-010
+ lua=-3.0403944e-018       wua=-1.8150918e-016       pua=2.4504125e-023
+ ub=1.0375255e-018         lub=5.6717762e-026        wub=1.5019932e-025
+ pub=-1.9075175e-031       uc=3.0118597e-011         luc=2.7509631e-017
+ wuc=-4.5781457e-018       puc=-3.3178429e-023       vsat=160000+dvsatp_hv18_spw
+ a0=2.0025839+da0p_hv18_spw                          la0=-7.8479666e-007+dla0p_hv18_spw
+ wa0=2.8250488e-007+dwa0p_hv18_spw                   pa0=-4.6164436e-014+dpa0p_hv18_spw
+ ags=0.48491223+dagsp_hv18_spw+0.00378173*ff_flag_hv18_snw_spw-0.0141815*ss_flag_hv18_snw_spw
+ lags=4.8471991e-007+dlagsp_hv18_spw-3.69316e-08*ff_flag_hv18_snw_spw+1.38494e-07*ss_flag_hv18_snw_spw
+ wags=2.7783406e-008+dwagsp_hv18_spw-3.78173e-08*ff_flag_hv18_snw_spw+1.41815e-07*ss_flag_hv18_snw_spw
+ pags=-2.270555e-013+dpagsp_hv18_spw+3.69316e-13*ff_flag_hv18_snw_spw-1.38494e-12*ss_flag_hv18_snw_spw
+ a1=0                      a2=1                      b0=0
+ b1=0                      keta=-0.037900915         lketa=-4.436371e-008
+ wketa=-8.4954512e-010     pketa=5.5295785e-015      dwg=0
+ dwb=0                     pclm=0.3454944            lpclm=-4.1548017e-008
+ pdiblc1=0                 pdiblc2=0.0001            pdiblcb=0
+ drout=0.56                pvag=0                    delta=0.01
+ pscbe1=9.264e+008         pscbe2=1e-020             fprout=50
+ pdits=0                   pditsd=0                  rsh=15.2
+ rsw=169.8                 rdw=1980.2                prwg=0
+ prwb=0                    wr=1                      alpha0=1.5106e-08
+ alpha1=0.024473           beta0=30                  agidl=1e-007+dagidlp_hv18_spw
+ bgidl=9e+009+dbgidlp_hv18_spw                       cgidl=10
+ egidl=0.902               aigbacc=0.01238           bigbacc=0.006109
+ cigbacc=0.2809            nigbacc=4.05              aigbinv=0.35
+ bigbinv=0.03              cigbinv=0.006             eigbinv=1.1
+ nigbinv=1                 aigc=0.009898             bigc=0.001383
+ cigc=1.515e-005           aigsd=0.0086              bigsd=0.0004353
+ cigsd=3.925e-020          nigc=1                    poxedge=1
+ pigcd=1.672               ntox=1                    xrcrg1=12
+ xrcrg2=1                  cgso=cgsop_hv18_spw       cgdo=cgdop_hv18_spw
+ cgbo=0                    cgdl=cgdlp_hv18_spw       cgsl=cgslp_hv18_spw
+ clc=1e-007                cle=0.6                   cf=cfp_hv18_spw
+ ckappas=0.6               ckappad=0.6               acde=0.4
+ moin=6.5786               noff=2.289                voffcv=-0.0744
+ tvoff=0.0015              ltvoff=0                  wtvoff=0
+ ptvoff=0                  kt1=-0.24571573+dkt1p_hv18_spw
+ lkt1=-3.7716367e-008+dlkt1p_hv18_spw                wkt1=3.8459253e-008+dwkt1p_hv18_spw
+ pkt1=-1.4467943e-014+dpkt1p_hv18_spw                kt1l=0
+ kt2=-0.020172014          lkt2=-2.6531641e-008      wkt2=-9.1446681e-009
+ pkt2=1.9751004e-014       ute=-0.97447362           lute=-2.492881e-007
+ ua1=7.2612197e-010        lua1=-7.0127514e-017      wua1=6.8209162e-017
+ pua1=1.7851798e-022       ub1=-9.6594249e-020       lub1=-9.8835439e-025
+ wub1=-2.8047187e-025      pub1=3.1844247e-032       uc1=-1.9558299e-010
+ luc1=2.3868717e-016       wuc1=2.5604142e-016       puc1=-2.375097e-022
+ prt=0                     at=10399.637+datp_hv18_spw
+ lat=-0.10156182+dlatp_hv18_spw                      wat=0.0066179512+dwatp_hv18_spw
+ pat=-6.4630249e-008+dpatp_hv18_spw                  jss=1.67e-007
+ jsws=4.74e-013            jswgs=4.74e-013           njs=1.02
+ njd=1.02                  ijthsfwd=0.01             ijthdfwd=0.01
+ ijthsrev=0.01             ijthdrev=0.01             bvs=8.2
+ xjbvs=1                   xjbvd=1                   jsd=1.57e-007
+ jswd=4.56e-013            jswgd=4.56e-013           bvd=14.2
+ jtsswgs=1e-009+djtsswgsp_hv18_spw                   jtsswgd=5e-008+djtsswgdp_hv18_spw
+ njtsswg=8+dnjtsswgp_hv18_spw                        xtsswgs=0.1
+ xtsswgd=0.45              tnjtsswg=1                vtsswgs=0.6
+ vtsswgd=0.1               pbs=0.5                   cjs=cjsp_hv18_spw
+ mjs=0.24                  pbsws=0.9                 cjsws=cjswsp_hv18_spw
+ mjsws=0.02                pbswgs=0.5                cjswgs=cjswgsp_hv18_spw
+ mjswgs=0.7                pbd=0.6                   cjd=cjdp_hv18_spw
+ mjd=0.31                  pbswd=0.7                 cjswd=cjswdp_hv18_spw
+ mjswd=0.35                pbswgd=0.8                cjswgd=cjswgdp_hv18_spw
+ mjswgd=0.43               tpb=0.00155               tcj=0.0011
+ tpbsw=0.0018              tcjsw=0.0011              tpbswg=0.0018
+ tcjswg=0.00118            xtis=3                    xtid=3
+ dmcg=6.4e-08              dmci=6.4e-08              dmdg=0
+ dmcgt=0                   dwj=0                     xgw=0
+ xgl=-8.2e-09              rshg=14.1                 gbmin=1e-012
+ rbpb=50                   rbpd=50                   rbps=50
+ rbdb=50                   rbsb=50                   ngcon=1
+ lvsat=0+dlvsatp_hv18_spw  wnfactor=0+dwnfactorp_hv18_spw
+ lnfactor=0+dlnfactorp_hv18_spw                      pnfactor=0+dpnfactorp_hv18_spw
+ pvsat=0+dpvsatp_hv18_spw  wvsat=0+dwvsatp_hv18_spw  weta0=0+dweta0p_hv18_spw
+ lagidl=0+dlagidlp_hv18_spw                          wagidl=0+dwagidlp_hv18_spw
+ pagidl=0+dpagidlp_hv18_spw                          lbgidl=0+dlbgidlp_hv18_spw
+ wbgidl=0+dwbgidlp_hv18_spw                          pbgidl=0+dpbgidlp_hv18_spw
+ minr=1e-3

     13: type=p
+ lmin=8e-007-dxlp_hv18_spw lmax=1e-006-dxlp_hv18_spw wmin=1e-006-dxwp_hv18_spw
+ wmax=1e-005-dxwp_hv18_spw version=4.5               binunit=2
+ paramchk=1                mobmod=0                  capmod=2
+ igcmod=0                  igbmod=0                  diomod=1
+ rdsmod=1                  rbodymod=0                rgeomod=1
+ rgatemod=1*rgflag_hv18_snw_spw                      permod=1
+ acnqsmod=0                trnqsmod=0                tempmod=0
+ tnom=25                   toxe=toxp_hv18_spw        toxm=3.85e-009
+ dtox=3.8e-010             epsrox=3.9                wint=0
+ lint=1.221e-007           ll=0                      wl=0
+ lln=1                     wln=1                     lw=0
+ ww=0                      lwn=1                     wwn=1
+ lwl=0                     wwl=0                     llc=0
+ wlc=0                     lwc=0                     wwc=0
+ lwlc=0                    wwlc=0                    xl=1e-08+dxlp_hv18_spw
+ xw=0+dxwp_hv18_spw        dlc=ddlcp_hv18_spw        dwc=0
+ xpart=1                   toxref=3e-009             dlcig=2.5e-009
+ vth0=-0.43710196+dvthp_hv18_spw                     lvth0=-7.0048492e-010+dlvthp_hv18_spw
+ wvth0=5.8424867e-008+dwvthp_hv18_spw                pvth0=-4.867287e-014+dpvthp_hv18_spw
+ k1=0.332                  k2=0.039805372+dk2p_hv18_spw
+ lk2=2.8524901e-009+dlk2p_hv18_spw                   wk2=-3.4439922e-009+dwk2p_hv18_spw
+ pk2=-1.1626605e-015+dpk2p_hv18_spw                  k3=-2.3465
+ k3b=1                     w0=0                      dvt0=0.75418
+ dvt1=0.034455             dvt2=0                    dvt0w=0
+ dvt1w=0                   dvt2w=0                   dsub=0.4
+ minv=-0.29858036          lminv=1.9257317e-010      wminv=3.4035556e-010
+ pminv=-1.9257317e-016     voffl=-5e-009             dvtp0=2.5e-007
+ dvtp1=0.08                lpe0=1.4918e-007          lpeb=7.0022e-008
+ xj=8.5e-008               ngate=2.092e+020          ndep=6e+017
+ nsd=1e+020                phin=0.174                cdsc=0
+ cdscb=0                   cdscd=0                   cit=0.0013054197+dcitp_hv18_spw
+ lcit=-1.7163084e-010+dlcitp_hv18_spw                wcit=-3.4208667e-011+dwcitp_hv18_spw
+ pcit=4.3810397e-017+dpcitp_hv18_spw                 voff=-0.096444958+dvoffp_hv18_spw
+ lvoff=1.3022592e-009+dlvoffp_hv18_spw               wvoff=6.3169098e-008+dwvoffp_hv18_spw
+ pvoff=-5.2560424e-014+dpvoffp_hv18_spw              nfactor=0.7+dnfactorp_hv18_spw
+ eta0=0.028556+deta0p_hv18_spw                       etab=-0.398
+ ud=0                      lud=0                     wud=0
+ pud=0                     u0=0.011474955+du0p_hv18_spw
+ lu0=2.2747706e-010+dlu0p_hv18_spw                   wu0=-2.04387e-009+dwu0p_hv18_spw
+ pu0=2.2314416e-015+dpu0p_hv18_spw                   ua=6.3513878e-010
+ lua=-9.8693751e-018       wua=-1.0949648e-016       pua=-3.0643206e-023
+ ub=1.1439652e-018         lub=-2.4793796e-026       wub=-6.6594622e-025
+ pub=4.3425251e-031        uc=5.41523e-011           luc=9.1046208e-018
+ wuc=-9.380229e-017        puc=3.5149421e-023        vsat=160000+dvsatp_hv18_spw
+ a0=2.3294105+da0p_hv18_spw                          la0=-1.0350804e-006+dla0p_hv18_spw
+ wa0=8.5088898e-007+dwa0p_hv18_spw                   pa0=-4.8143298e-013+dpa0p_hv18_spw
+ ags=-0.99588225+dagsp_hv18_spw-0.0130113*ff_flag_hv18_snw_spw+0.00950033*ss_flag_hv18_snw_spw
+ lags=1.6187123e-006+dlagsp_hv18_spw-2.40716e-08*ff_flag_hv18_snw_spw+1.20358e-07*ss_flag_hv18_snw_spw
+ wags=2.3692549e-007+dwagsp_hv18_spw+1.30113e-07*ff_flag_hv18_snw_spw-9.50033e-08*ss_flag_hv18_snw_spw
+ pags=-3.8721651e-013+dpagsp_hv18_spw+2.40716e-13*ff_flag_hv18_snw_spw-1.20358e-12*ss_flag_hv18_snw_spw
+ a1=0                      a2=1                      b0=0
+ b1=0                      keta=-0.041672163         lketa=-4.1475688e-008
+ wketa=-1.2004816e-008     pketa=1.4072285e-014      dwg=0
+ dwb=0                     pclm=0.14979              lpclm=1.0832241e-007
+ pdiblc1=0                 pdiblc2=0.0001            pdiblcb=0
+ drout=0.56                pvag=0                    delta=0.01
+ pscbe1=9.264e+008         pscbe2=1e-020             fprout=50
+ pdits=0                   pditsd=0                  rsh=15.2
+ rsw=169.8                 rdw=1980.2                prwg=0
+ prwb=0                    wr=1                      alpha0=1.5106e-08
+ alpha1=0.024473           beta0=30                  agidl=1e-007+dagidlp_hv18_spw
+ bgidl=9e+009+dbgidlp_hv18_spw                       cgidl=10
+ egidl=0.902               aigbacc=0.01238           bigbacc=0.006109
+ cigbacc=0.2809            nigbacc=4.05              aigbinv=0.35
+ bigbinv=0.03              cigbinv=0.006             eigbinv=1.1
+ nigbinv=1                 aigc=0.009898             bigc=0.001383
+ cigc=1.515e-005           aigsd=0.0086              bigsd=0.0004353
+ cigsd=3.925e-020          nigc=1                    poxedge=1
+ pigcd=1.672               ntox=1                    xrcrg1=12
+ xrcrg2=1                  cgso=cgsop_hv18_spw       cgdo=cgdop_hv18_spw
+ cgbo=0                    cgdl=cgdlp_hv18_spw       cgsl=cgslp_hv18_spw
+ clc=1e-007                cle=0.6                   cf=cfp_hv18_spw
+ ckappas=0.6               ckappad=0.6               acde=0.4
+ moin=6.5786               noff=2.289                voffcv=-0.0744
+ tvoff=0.0015              ltvoff=0                  wtvoff=0
+ ptvoff=0                  kt1=-0.31586983+dkt1p_hv18_spw
+ lkt1=1.6007645e-008+dlkt1p_hv18_spw                 wkt1=7.5832333e-008+dwkt1p_hv18_spw
+ pkt1=-4.3088247e-014+dpkt1p_hv18_spw                kt1l=0
+ kt2=-0.11238876           lkt2=4.4087943e-008       wkt2=7.1142637e-008
+ pkt2=-4.1733014e-014      ute=-1.3                  ua1=1.9401723e-009
+ lua1=-9.9984723e-016      wua1=-2.1512634e-015      pua1=1.8781901e-021
+ ub1=-3.2097158e-018       lub1=1.3956741e-024       wub1=3.2538574e-024
+ pub1=-2.6747451e-030      uc1=2.7215847e-010        luc1=-1.1950923e-016
+ wuc1=-1.2945959e-016      puc1=5.7706971e-023       prt=0
+ at=154391.11+datp_hv18_spw                          lat=-0.21183049+dlatp_hv18_spw
+ wat=-0.29781114+dwatp_hv18_spw                      pat=1.6850155e-007+dpatp_hv18_spw
+ jss=1.67e-007             jsws=4.74e-013            jswgs=4.74e-013
+ njs=1.02                  njd=1.02                  ijthsfwd=0.01
+ ijthdfwd=0.01             ijthsrev=0.01             ijthdrev=0.01
+ bvs=8.2                   xjbvs=1                   xjbvd=1
+ jsd=1.57e-007             jswd=4.56e-013            jswgd=4.56e-013
+ bvd=14.2                  jtsswgs=1e-009+djtsswgsp_hv18_spw
+ jtsswgd=5e-008+djtsswgdp_hv18_spw                   njtsswg=8+dnjtsswgp_hv18_spw
+ xtsswgs=0.1               xtsswgd=0.45              tnjtsswg=1
+ vtsswgs=0.6               vtsswgd=0.1               pbs=0.5
+ cjs=cjsp_hv18_spw         mjs=0.24                  pbsws=0.9
+ cjsws=cjswsp_hv18_spw     mjsws=0.02                pbswgs=0.5
+ cjswgs=cjswgsp_hv18_spw   mjswgs=0.7                pbd=0.6
+ cjd=cjdp_hv18_spw         mjd=0.31                  pbswd=0.7
+ cjswd=cjswdp_hv18_spw     mjswd=0.35                pbswgd=0.8
+ cjswgd=cjswgdp_hv18_spw   mjswgd=0.43               tpb=0.00155
+ tcj=0.0011                tpbsw=0.0018              tcjsw=0.0011
+ tpbswg=0.0018             tcjswg=0.00118            xtis=3
+ xtid=3                    dmcg=6.4e-08              dmci=6.4e-08
+ dmdg=0                    dmcgt=0                   dwj=0
+ xgw=0                     xgl=-8.2e-09              rshg=14.1
+ gbmin=1e-012              rbpb=50                   rbpd=50
+ rbps=50                   rbdb=50                   rbsb=50
+ ngcon=1                   lvsat=0+dlvsatp_hv18_spw  wnfactor=0+dwnfactorp_hv18_spw
+ lnfactor=0+dlnfactorp_hv18_spw                      pnfactor=0+dpnfactorp_hv18_spw
+ pvsat=0+dpvsatp_hv18_spw  wvsat=0+dwvsatp_hv18_spw  weta0=0+dweta0p_hv18_spw
+ lagidl=0+dlagidlp_hv18_spw                          wagidl=0+dwagidlp_hv18_spw
+ pagidl=0+dpagidlp_hv18_spw                          lbgidl=0+dlbgidlp_hv18_spw
+ wbgidl=0+dwbgidlp_hv18_spw                          pbgidl=0+dpbgidlp_hv18_spw
+ minr=1e-3

     14: type=p
+ lmin=7e-007-dxlp_hv18_spw lmax=8e-007-dxlp_hv18_spw wmin=1e-006-dxwp_hv18_spw
+ wmax=1e-005-dxwp_hv18_spw version=4.5               binunit=2
+ paramchk=1                mobmod=0                  capmod=2
+ igcmod=0                  igbmod=0                  diomod=1
+ rdsmod=1                  rbodymod=0                rgeomod=1
+ rgatemod=1*rgflag_hv18_snw_spw                      permod=1
+ acnqsmod=0                trnqsmod=0                tempmod=0
+ tnom=25                   toxe=toxp_hv18_spw        toxm=3.85e-009
+ dtox=3.8e-010             epsrox=3.9                wint=0
+ lint=1.221e-007           ll=0                      wl=0
+ lln=1                     wln=1                     lw=0
+ ww=0                      lwn=1                     wwn=1
+ lwl=0                     wwl=0                     llc=0
+ wlc=0                     lwc=0                     wwc=0
+ lwlc=0                    wwlc=0                    xl=1e-08+dxlp_hv18_spw
+ xw=0+dxwp_hv18_spw        dlc=ddlcp_hv18_spw        dwc=0
+ xpart=1                   toxref=3e-009             dlcig=2.5e-009
+ vth0=-0.50486659+dvthp_hv18_spw                     lvth0=3.7640745e-008+dlvthp_hv18_spw
+ wvth0=4.3305111e-008+dwvthp_hv18_spw                pvth0=-4.0118112e-014+dpvthp_hv18_spw
+ k1=0.332                  k2=0.03961906+dk2p_hv18_spw
+ lk2=2.9579055e-009+dlk2p_hv18_spw                   wk2=-6.3683822e-009+dwk2p_hv18_spw
+ pk2=4.9195933e-016+dpk2p_hv18_spw                   k3=-2.3465
+ k3b=1                     w0=0                      dvt0=0.75418
+ dvt1=0.034455             dvt2=0                    dvt0w=0
+ dvt1w=0                   dvt2w=0                   dsub=0.4
+ minv=-0.29786736          lminv=-2.1083971e-010     voffl=-5e-009
+ dvtp0=2.5e-007            dvtp1=0.08                lpe0=1.4918e-007
+ lpeb=7.0022e-008          xj=8.5e-008               ngate=2.092e+020
+ ndep=6e+017               nsd=1e+020                phin=0.174
+ cdsc=0                    cdscb=0                   cdscd=0
+ cit=-0.00010067784+dcitp_hv18_spw                   lcit=6.2393913e-010+dlcitp_hv18_spw
+ wcit=1.2144504e-009+dwcitp_hv18_spw                 pcit=-6.6268093e-016+dpcitp_hv18_spw
+ voff=-0.1647741+dvoffp_hv18_spw                     lvoff=3.996289e-008+dlvoffp_hv18_spw
+ wvoff=4.136995e-008+dwvoffp_hv18_spw                pvoff=-4.0226466e-014+dpvoffp_hv18_spw
+ nfactor=0.7+dnfactorp_hv18_spw                      eta0=0.028556+deta0p_hv18_spw
+ etab=-0.398               ud=0                      lud=0
+ wud=0                     pud=0                     u0=0.011269907+du0p_hv18_spw
+ lu0=3.4349303e-010+dlu0p_hv18_spw                   wu0=5.6419267e-009+dwu0p_hv18_spw
+ pu0=-2.1171821e-015+dpu0p_hv18_spw                  ua=8.1233785e-010
+ lua=-1.1012861e-016       wua=6.7680291e-016        pua=-4.755314e-022
+ ub=6.2005991e-019         lub=2.7163183e-025        wub=7.2883289e-025
+ pub=-3.5491352e-031       uc=1.1937627e-011         luc=3.2989683e-017
+ wuc=7.058492e-017         puc=-5.7860862e-023       vsat=160000+dvsatp_hv18_spw
+ a0=0.91730532+da0p_hv18_spw                         la0=-2.3611132e-007+dla0p_hv18_spw
+ wa0=5.1429502e-007+dwa0p_hv18_spw                   pa0=-2.9098812e-013+dpa0p_hv18_spw
+ ags=-1.8962393+dagsp_hv18_spw-0.210822*ff_flag_hv18_snw_spw+0.273974*ss_flag_hv18_snw_spw
+ lags=2.1281343e-006+dlagsp_hv18_spw+8.78494e-08*ff_flag_hv18_snw_spw-2.92834e-08*ss_flag_hv18_snw_spw
+ wags=3.53214e-007+dwagsp_hv18_spw+2.10822e-06*ff_flag_hv18_snw_spw-2.73974e-06*ss_flag_hv18_snw_spw
+ pags=-4.5301255e-013+dpagsp_hv18_spw-8.78494e-13*ff_flag_hv18_snw_spw+2.92834e-13*ss_flag_hv18_snw_spw
+ a1=0                      a2=1                      b0=0
+ b1=0                      keta=-0.059179002         lketa=-3.1570319e-008
+ wketa=-1.9871778e-009     pketa=8.4043052e-015      dwg=0
+ dwb=0                     pclm=0.34124              pdiblc1=0
+ pdiblc2=0.0001            pdiblcb=0                 drout=0.56
+ pvag=0                    delta=0.01                pscbe1=9.264e+008
+ pscbe2=1e-020             fprout=50                 pdits=0
+ pditsd=0                  rsh=15.2                  rsw=169.8
+ rdw=1980.2                prwg=0                    prwb=0
+ wr=1                      alpha0=1.5106e-08         alpha1=0.024473
+ beta0=30                  agidl=1e-007+dagidlp_hv18_spw
+ bgidl=9e+009+dbgidlp_hv18_spw                       cgidl=10
+ egidl=0.902               aigbacc=0.01238           bigbacc=0.006109
+ cigbacc=0.2809            nigbacc=4.05              aigbinv=0.35
+ bigbinv=0.03              cigbinv=0.006             eigbinv=1.1
+ nigbinv=1                 aigc=0.009898             bigc=0.001383
+ cigc=1.515e-005           aigsd=0.0086              bigsd=0.0004353
+ cigsd=3.925e-020          nigc=1                    poxedge=1
+ pigcd=1.672               ntox=1                    xrcrg1=12
+ xrcrg2=1                  cgso=cgsop_hv18_spw       cgdo=cgdop_hv18_spw
+ cgbo=0                    cgdl=cgdlp_hv18_spw       cgsl=cgslp_hv18_spw
+ clc=1e-007                cle=0.6                   cf=cfp_hv18_spw
+ ckappas=0.6               ckappad=0.6               acde=0.4
+ moin=6.5786               noff=2.289                voffcv=-0.0744
+ tvoff=0.0015              ltvoff=0                  wtvoff=0
+ ptvoff=0                  kt1=-0.24892155+dkt1p_hv18_spw
+ lkt1=-2.1871692e-008+dlkt1p_hv18_spw                wkt1=-2.4492067e-008+dwkt1p_hv18_spw
+ pkt1=1.3675298e-014+dpkt1p_hv18_spw                 kt1l=0
+ kt2=0.050770962           lkt2=-4.8227827e-008      wkt2=-5.8854258e-008
+ pkt2=3.181923e-014        ute=-1.3                  ua1=-3.5825571e-009
+ lua1=2.124913e-015        wua1=5.6835768e-015       pua1=-2.5547625e-021
+ ub1=4.7059914e-018        lub1=-3.083033e-024       wub1=-9.557522e-024
+ pub1=4.5739333e-030       uc1=-7.9268524e-011       luc1=7.9328158e-017
+ wuc1=-2.4537417e-016      puc1=1.2329144e-022       prt=0
+ at=-80259.96+datp_hv18_spw                          lat=-0.079064915+dlatp_hv18_spw
+ wat=6.2866667e-008+dwatp_hv18_spw                   pat=-2.9283293e-014+dpatp_hv18_spw
+ jss=1.67e-007             jsws=4.74e-013            jswgs=4.74e-013
+ njs=1.02                  njd=1.02                  ijthsfwd=0.01
+ ijthdfwd=0.01             ijthsrev=0.01             ijthdrev=0.01
+ bvs=8.2                   xjbvs=1                   xjbvd=1
+ jsd=1.57e-007             jswd=4.56e-013            jswgd=4.56e-013
+ bvd=14.2                  jtsswgs=1e-009+djtsswgsp_hv18_spw
+ jtsswgd=5e-008+djtsswgdp_hv18_spw                   njtsswg=8+dnjtsswgp_hv18_spw
+ xtsswgs=0.1               xtsswgd=0.45              tnjtsswg=1
+ vtsswgs=0.6               vtsswgd=0.1               pbs=0.5
+ cjs=cjsp_hv18_spw         mjs=0.24                  pbsws=0.9
+ cjsws=cjswsp_hv18_spw     mjsws=0.02                pbswgs=0.5
+ cjswgs=cjswgsp_hv18_spw   mjswgs=0.7                pbd=0.6
+ cjd=cjdp_hv18_spw         mjd=0.31                  pbswd=0.7
+ cjswd=cjswdp_hv18_spw     mjswd=0.35                pbswgd=0.8
+ cjswgd=cjswgdp_hv18_spw   mjswgd=0.43               tpb=0.00155
+ tcj=0.0011                tpbsw=0.0018              tcjsw=0.0011
+ tpbswg=0.0018             tcjswg=0.00118            xtis=3
+ xtid=3                    dmcg=6.4e-08              dmci=6.4e-08
+ dmdg=0                    dmcgt=0                   dwj=0
+ xgw=0                     xgl=-8.2e-09              rshg=14.1
+ gbmin=1e-012              rbpb=50                   rbpd=50
+ rbps=50                   rbdb=50                   rbsb=50
+ ngcon=1                   lvsat=0+dlvsatp_hv18_spw  wnfactor=0+dwnfactorp_hv18_spw
+ lnfactor=0+dlnfactorp_hv18_spw                      pnfactor=0+dpnfactorp_hv18_spw
+ pvsat=0+dpvsatp_hv18_spw  wvsat=0+dwvsatp_hv18_spw  weta0=0+dweta0p_hv18_spw
+ lagidl=0+dlagidlp_hv18_spw                          wagidl=0+dwagidlp_hv18_spw
+ pagidl=0+dpagidlp_hv18_spw                          lbgidl=0+dlbgidlp_hv18_spw
+ wbgidl=0+dwbgidlp_hv18_spw                          pbgidl=0+dpbgidlp_hv18_spw
+ minr=1e-3

     15: type=p
+ lmin=0.594e-06            lmax=7e-007-dxlp_hv18_spw wmin=1e-006-dxwp_hv18_spw
+ wmax=1e-005-dxwp_hv18_spw version=4.5               binunit=2
+ paramchk=1                mobmod=0                  capmod=2
+ igcmod=0                  igbmod=0                  diomod=1
+ rdsmod=1                  rbodymod=0                rgeomod=1
+ rgatemod=1*rgflag_hv18_snw_spw                      permod=1
+ acnqsmod=0                trnqsmod=0                tempmod=0
+ tnom=25                   toxe=toxp_hv18_spw        toxm=3.85e-009
+ dtox=3.8e-010             epsrox=3.9                wint=0
+ lint=1.221e-007           ll=0                      wl=0
+ lln=1                     wln=1                     lw=0
+ ww=0                      lwn=1                     wwn=1
+ lwl=0                     wwl=0                     llc=0
+ wlc=0                     lwc=0                     wwc=0
+ lwlc=0                    wwlc=0                    xl=1e-08+dxlp_hv18_spw
+ xw=0+dxwp_hv18_spw        dlc=ddlcp_hv18_spw        dwc=0
+ xpart=1                   toxref=3e-009             dlcig=2.5e-009
+ vth0=-0.40677839+dvthp_hv18_spw                     lvth0=-8.048733e-09+dlvthp_hv18_spw
+ wvth0=-1.3081217e-07+dwvthp_hv18_spw                pvth0=4.0985713e-14+dpvthp_hv18_spw
+ k1=0.332                  k2=0.06616504+dk2p_hv18_spw
+ lk2=-9.407212e-009+dlk2p_hv18_spw                   wk2=7.5273578e-009+dwk2p_hv18_spw
+ pk2=-5.9806764e-015+dpk2p_hv18_spw                  k3=-2.3465
+ k3b=1                     w0=0                      dvt0=0.75418
+ dvt1=0.034455             dvt2=0                    dvt0w=0
+ dvt1w=0                   dvt2w=0                   dsub=0.4
+ minv=-0.29506844          lminv=-1.5145746e-009     wminv=-3.2515556e-009
+ pminv=1.5145746e-015      voffl=-5e-009             dvtp0=2.5e-007
+ dvtp1=0.08                lpe0=1.4918e-007          lpeb=7.0022e-008
+ xj=8.5e-008               ngate=2.092e+020          ndep=6e+017
+ nsd=1e+020                phin=0.174                cdsc=0
+ cdscb=0                   cdscd=0                   cit=0.0013748267+dcitp_hv18_spw
+ lcit=-6.3350876e-011+dlcitp_hv18_spw                wcit=1.0152152e-012+dwcitp_hv18_spw
+ pcit=-9.7462798e-017+dpcitp_hv18_spw                voff=-0.055622482+dvoffp_hv18_spw
+ lvoff=-1.0879936e-008+dlvoffp_hv18_spw              wvoff=-1.6509436e-007+dwvoffp_hv18_spw
+ pvoff=5.594461e-014+dpvoffp_hv18_spw                nfactor=0.7+dnfactorp_hv18_spw
+ eta0=0.028556+deta0p_hv18_spw                       etab=-0.398
+ ud=0                      lud=0                     wud=0
+ pud=0                     u0=0.011821588+du0p_hv18_spw
+ lu0=8.6520073e-011+dlu0p_hv18_spw                   wu0=7.5931778e-010+dwu0p_hv18_spw
+ pu0=1.5713711e-016+dpu0p_hv18_spw                   ua=2.0580944e-009
+ lua=-6.90402e-016         wua=-1.8585012e-015       pua=7.0541326e-022
+ ub=-1.1462007e-018        lub=1.094356e-024         wub=2.5189532e-024
+ pub=-1.1887515e-030       uc=7.2749517e-011         luc=4.6635044e-018
+ wuc=4.8423651e-017        puc=-4.7538143e-023       vsat=160000+dvsatp_hv18_spw
+ a0=-0.079882758+da0p_hv18_spw-0.369864*ff_flag_hv18_snw_spw+0.609666*ss_flag_hv18_snw_spw
+ la0=2.2837888e-007+dla0p_hv18_spw+1.72283e-07*ff_flag_hv18_snw_spw-2.83983e-07*ss_flag_hv18_snw_spw
+ wa0=1.1114829e-006+dwa0p_hv18_spw+4.06444e-08*ff_flag_hv18_snw_spw-6.09667e-07*ss_flag_hv18_snw_spw
+ pa0=-5.6915823e-013+dpa0p_hv18_spw-1.89318e-14*ff_flag_hv18_snw_spw+2.83983e-13*ss_flag_hv18_snw_spw
+ ags=-1.4616325+dagsp_hv18_spw+1.52227*ff_flag_hv18_snw_spw-3.48753*ss_flag_hv18_snw_spw
+ lags=1.9256945e-06+dlagsp_hv18_spw-7.19423e-07*ff_flag_hv18_snw_spw+1.72283e-06*ss_flag_hv18_snw_spw
+ wags=-6.5463534e-06+dwagsp_hv18_spw-5.90668e-07*ff_flag_hv18_snw_spw-1.70468e-06*ss_flag_hv18_snw_spw
+ pags=2.760806e-12+dpagsp_hv18_spw+3.78643e-13*ff_flag_hv18_snw_spw-1.89328e-13*ss_flag_hv18_snw_spw
+ a1=0                      a2=1                      b0=0
+ b1=0                      keta=-0.050991089         lketa=-3.5384249e-008
+ wketa=-4.9300711e-008     pketa=3.0442949e-014      dwg=0
+ dwb=0                     pclm=0.14478914           lpclm=9.150681e-008
+ wpclm=-1.8493222e-007     ppclm=8.6141429e-014      pdiblc1=0
+ pdiblc2=0.0001            pdiblcb=0                 drout=0.56
+ pvag=0                    delta=0.01                pscbe1=9.264e+008
+ pscbe2=1e-020             fprout=50                 pdits=0
+ pditsd=0                  rsh=15.2                  rsw=169.8
+ rdw=1980.2                prwg=0                    prwb=0
+ wr=1                      alpha0=1.5106e-08         alpha1=0.024473
+ beta0=30                  agidl=1e-007+dagidlp_hv18_spw
+ bgidl=9e+009+dbgidlp_hv18_spw                       cgidl=10
+ egidl=0.902               aigbacc=0.01238           bigbacc=0.006109
+ cigbacc=0.2809            nigbacc=4.05              aigbinv=0.35
+ bigbinv=0.03              cigbinv=0.006             eigbinv=1.1
+ nigbinv=1                 aigc=0.009898             bigc=0.001383
+ cigc=1.515e-005           aigsd=0.0086              bigsd=0.0004353
+ cigsd=3.925e-020          nigc=1                    poxedge=1
+ pigcd=1.672               ntox=1                    xrcrg1=12
+ xrcrg2=1                  cgso=cgsop_hv18_spw       cgdo=cgdop_hv18_spw
+ cgbo=0                    cgdl=cgdlp_hv18_spw       cgsl=cgslp_hv18_spw
+ clc=1e-007                cle=0.6                   cf=cfp_hv18_spw
+ ckappas=0.6               ckappad=0.6               acde=0.4
+ moin=6.5786               noff=2.289                voffcv=-0.0744
+ tvoff=0.0015              ltvoff=0                  wtvoff=0
+ ptvoff=0                  kt1=-0.18685607+dkt1p_hv18_spw
+ lkt1=-5.0781792e-008+dlkt1p_hv18_spw                wkt1=-8.3047267e-008+dwkt1p_hv18_spw
+ pkt1=4.095031e-014+dpkt1p_hv18_spw                  kt1l=0
+ kt2=-0.11602281           lkt2=2.9464713e-008       wkt2=9.7122674e-008
+ pkt2=-4.0834826e-014      ute=-1.3                  ua1=5.8716245e-010
+ lua1=1.8265767e-016       wua1=4.5093568e-016       pua1=-1.1739827e-022
+ ub1=-3.1759074e-018       lub1=5.8835543e-025       wub1=1.7252e-024
+ pub1=-6.8155856e-031      uc1=-6.5139616e-011       luc1=7.2746913e-017
+ wuc1=3.292354e-016        puc1=-1.443617e-022       prt=0
+ at=-250000.05+datp_hv18_spw                         lat=1.7038964e-008+dlatp_hv18_spw
+ jss=1.67e-007             jsws=4.74e-013            jswgs=4.74e-013
+ njs=1.02                  njd=1.02                  ijthsfwd=0.01
+ ijthdfwd=0.01             ijthsrev=0.01             ijthdrev=0.01
+ bvs=8.2                   xjbvs=1                   xjbvd=1
+ jsd=1.57e-007             jswd=4.56e-013            jswgd=4.56e-013
+ bvd=14.2                  jtsswgs=1e-009+djtsswgsp_hv18_spw
+ jtsswgd=5e-008+djtsswgdp_hv18_spw                   njtsswg=8+dnjtsswgp_hv18_spw
+ xtsswgs=0.1               xtsswgd=0.45              tnjtsswg=1
+ vtsswgs=0.6               vtsswgd=0.1               pbs=0.5
+ cjs=cjsp_hv18_spw         mjs=0.24                  pbsws=0.9
+ cjsws=cjswsp_hv18_spw     mjsws=0.02                pbswgs=0.5
+ cjswgs=cjswgsp_hv18_spw   mjswgs=0.7                pbd=0.6
+ cjd=cjdp_hv18_spw         mjd=0.31                  pbswd=0.7
+ cjswd=cjswdp_hv18_spw     mjswd=0.35                pbswgd=0.8
+ cjswgd=cjswgdp_hv18_spw   mjswgd=0.43               tpb=0.00155
+ tcj=0.0011                tpbsw=0.0018              tcjsw=0.0011
+ tpbswg=0.0018             tcjswg=0.00118            xtis=3
+ xtid=3                    dmcg=6.4e-08              dmci=6.4e-08
+ dmdg=0                    dmcgt=0                   dwj=0
+ xgw=0                     xgl=-8.2e-09              rshg=14.1
+ gbmin=1e-012              rbpb=50                   rbpd=50
+ rbps=50                   rbdb=50                   rbsb=50
+ ngcon=1                   lvsat=0+dlvsatp_hv18_spw  wnfactor=0+dwnfactorp_hv18_spw
+ lnfactor=0+dlnfactorp_hv18_spw                      pnfactor=0+dpnfactorp_hv18_spw
+ pvsat=0+dpvsatp_hv18_spw  wvsat=0+dwvsatp_hv18_spw  weta0=0+dweta0p_hv18_spw
+ wat=0+dwatp_hv18_spw      pat=0+dpatp_hv18_spw      lagidl=0+dlagidlp_hv18_spw
+ wagidl=0+dwagidlp_hv18_spw                          pagidl=0+dpagidlp_hv18_spw
+ lbgidl=0+dlbgidlp_hv18_spw                          wbgidl=0+dwbgidlp_hv18_spw
+ pbgidl=0+dpbgidlp_hv18_spw                          minr=1e-3

     16: type=p
+ lmin=1e-005-dxlp_hv18_spw lmax=900.001e-6           wmin=0.6e-06
+ wmax=1e-006-dxwp_hv18_spw version=4.5               binunit=2
+ paramchk=1                mobmod=0                  capmod=2
+ igcmod=0                  igbmod=0                  diomod=1
+ rdsmod=1                  rbodymod=0                rgeomod=1
+ rgatemod=1*rgflag_hv18_snw_spw                      permod=1
+ acnqsmod=0                trnqsmod=0                tempmod=0
+ tnom=25                   toxe=toxp_hv18_spw        toxm=3.85e-009
+ dtox=3.8e-010             epsrox=3.9                wint=0
+ lint=1.221e-007           ll=0                      wl=0
+ lln=1                     wln=1                     lw=0
+ ww=0                      lwn=1                     wwn=1
+ lwl=0                     wwl=0                     llc=0
+ wlc=0                     lwc=0                     wwc=0
+ lwlc=0                    wwlc=0                    xl=1e-08+dxlp_hv18_spw
+ xw=0+dxwp_hv18_spw        dlc=ddlcp_hv18_spw        dwc=0
+ xpart=1                   toxref=3e-009             dlcig=2.5e-009
+ vth0=-0.44512501+dvthp_hv18_spw                     wvth0=-6.435e-009+dwvthp_hv18_spw
+ k1=0.332                  k2=0.030477989+dk2p_hv18_spw
+ wk2=-2.369955e-010+dwk2p_hv18_spw                   k3=-2.3465
+ k3b=1                     w0=0                      dvt0=0.75418
+ dvt1=0.034455             dvt2=0                    dvt0w=0
+ dvt1w=0                   dvt2w=0                   dsub=0.4
+ minv=-0.29832             voffl=-5e-009             dvtp0=2.5e-007
+ dvtp1=0.08                lpe0=1.4918e-007          lpeb=7.0022e-008
+ xj=8.5e-008               ngate=2.092e+020          ndep=6e+017
+ nsd=1e+020                phin=0.174                cdsc=0
+ cdscb=0                   cdscd=0                   cit=0.00021902498+dcitp_hv18_spw
+ wcit=7.389449e-10+dwcitp_hv18_spw                   voff=-0.115375+dvoffp_hv18_spw
+ wvoff=2.205e-09+dwvoffp_hv18_spw                    nfactor=0.7+dnfactorp_hv18_spw
+ eta0=0.028556+deta0p_hv18_spw                       etab=-1.4766124
+ wetab=1.0786124e-006      ud=0                      lud=0
+ wud=0                     pud=0                     u0=0.0118735+du0p_hv18_spw
+ wu0=2.085e-010+dwu0p_hv18_spw                       ua=5.62785e-010
+ wua=-1.1587503e-016       ub=1.13755e-018           wub=3.645015e-026
+ uc=3.1876455e-011         wuc=-6.9164715e-018       vsat=160000+dvsatp_hv18_spw
+ a0=2.4091007+da0p_hv18_spw                          wa0=-2.0909985e-007+dwa0p_hv18_spw
+ ags=0.60132968+dagsp_hv18_spw                       wags=-6.2249955e-008+dwagsp_hv18_spw
+ a1=0                      a2=1                      b0=0
+ b1=0                      keta=-0.04739946          wketa=4.672497e-009
+ dwg=0                     dwb=0                     pclm=0.34124002
+ wpclm=-1.5e-014           pdiblc1=0                 pdiblc2=0.0001
+ pdiblcb=0                 drout=0.56                pvag=0
+ delta=0.01                pscbe1=9.264e+008         pscbe2=1e-020
+ fprout=50                 pdits=0                   pditsd=0
+ rsh=15.2                  rsw=169.8                 rdw=1980.2
+ prwg=0                    prwb=0                    wr=1
+ alpha0=1.5106e-08         alpha1=0.024473           beta0=30
+ agidl=1e-007+dagidlp_hv18_spw                       bgidl=9e+009+dbgidlp_hv18_spw
+ cgidl=10                  egidl=0.902               aigbacc=0.01238
+ bigbacc=0.006109          cigbacc=0.2809            nigbacc=4.05
+ aigbinv=0.35              bigbinv=0.03              cigbinv=0.006
+ eigbinv=1.1               nigbinv=1                 aigc=0.009898
+ bigc=0.001383             cigc=1.515e-005           aigsd=0.0086
+ bigsd=0.0004353           cigsd=3.925e-020          nigc=1
+ poxedge=1                 pigcd=1.672               ntox=1
+ xrcrg1=12                 xrcrg2=1                  cgso=cgsop_hv18_spw
+ cgdo=cgdop_hv18_spw       cgbo=0                    cgdl=cgdlp_hv18_spw
+ cgsl=cgslp_hv18_spw       clc=1e-007                cle=0.6
+ cf=cfp_hv18_spw           ckappas=0.6               ckappad=0.6
+ acde=0.4                  moin=6.5786               noff=2.289
+ voffcv=-0.0744            tvoff=0.0015              ltvoff=0
+ wtvoff=0                  ptvoff=0                  kt1=-0.237425+dkt1p_hv18_spw
+ wkt1=2.4825e-008+dwkt1p_hv18_spw                    kt1l=0
+ kt2=-0.0438815            wkt2=1.38705e-008         ute=-1
+ ua1=1.23974e-009          wua1=-4.3431001e-016      ub1=-1.115327e-018
+ wub1=6.40317e-025         uc1=9.8911502e-011        wuc1=-3.8332501e-017
+ prt=0                     at=-0.00048500138+datp_hv18_spw
+ wat=3.4697775e-011+dwatp_hv18_spw                   jss=1.67e-007
+ jsws=4.74e-013            jswgs=4.74e-013           njs=1.02
+ njd=1.02                  ijthsfwd=0.01             ijthdfwd=0.01
+ ijthsrev=0.01             ijthdrev=0.01             bvs=8.2
+ xjbvs=1                   xjbvd=1                   jsd=1.57e-007
+ jswd=4.56e-013            jswgd=4.56e-013           bvd=14.2
+ jtsswgs=1e-009+djtsswgsp_hv18_spw                   jtsswgd=5e-008+djtsswgdp_hv18_spw
+ njtsswg=8+dnjtsswgp_hv18_spw                        xtsswgs=0.1
+ xtsswgd=0.45              tnjtsswg=1                vtsswgs=0.6
+ vtsswgd=0.1               pbs=0.5                   cjs=cjsp_hv18_spw
+ mjs=0.24                  pbsws=0.9                 cjsws=cjswsp_hv18_spw
+ mjsws=0.02                pbswgs=0.5                cjswgs=cjswgsp_hv18_spw
+ mjswgs=0.7                pbd=0.6                   cjd=cjdp_hv18_spw
+ mjd=0.31                  pbswd=0.7                 cjswd=cjswdp_hv18_spw
+ mjswd=0.35                pbswgd=0.8                cjswgd=cjswgdp_hv18_spw
+ mjswgd=0.43               tpb=0.00155               tcj=0.0011
+ tpbsw=0.0018              tcjsw=0.0011              tpbswg=0.0018
+ tcjswg=0.00118            xtis=3                    xtid=3
+ dmcg=6.4e-08              dmci=6.4e-08              dmdg=0
+ dmcgt=0                   dwj=0                     xgw=0
+ xgl=-8.2e-09              rshg=14.1                 gbmin=1e-012
+ rbpb=50                   rbpd=50                   rbps=50
+ rbdb=50                   rbsb=50                   ngcon=1
+ lvth0=0+dlvthp_hv18_spw   pvth0=0+dpvthp_hv18_spw   lu0=0+dlu0p_hv18_spw
+ pu0=0+dpu0p_hv18_spw      la0=0+dla0p_hv18_spw      pa0=0+dpa0p_hv18_spw
+ lags=0+dlagsp_hv18_spw    pags=0+dpagsp_hv18_spw    lvsat=0+dlvsatp_hv18_spw
+ wnfactor=0+dwnfactorp_hv18_spw                      lnfactor=0+dlnfactorp_hv18_spw
+ pnfactor=0+dpnfactorp_hv18_spw                      pvsat=0+dpvsatp_hv18_spw
+ wvsat=0+dwvsatp_hv18_spw  lk2=0+dlk2p_hv18_spw      pk2=0+dpk2p_hv18_spw
+ weta0=0+dweta0p_hv18_spw  lcit=0+dlcitp_hv18_spw    pcit=0+dpcitp_hv18_spw
+ lvoff=0+dlvoffp_hv18_spw  pvoff=0+dpvoffp_hv18_spw  lkt1=0+dlkt1p_hv18_spw
+ pkt1=0+dpkt1p_hv18_spw    lat=0+dlatp_hv18_spw      pat=0+dpatp_hv18_spw
+ lagidl=0+dlagidlp_hv18_spw                          wagidl=0+dwagidlp_hv18_spw
+ pagidl=0+dpagidlp_hv18_spw                          lbgidl=0+dlbgidlp_hv18_spw
+ wbgidl=0+dwbgidlp_hv18_spw                          pbgidl=0+dpbgidlp_hv18_spw
+ minr=1e-3

     17: type=p
+ lmin=1e-006-dxlp_hv18_spw lmax=1e-005-dxlp_hv18_spw wmin=0.6e-06
+ wmax=1e-006-dxwp_hv18_spw version=4.5               binunit=2
+ paramchk=1                mobmod=0                  capmod=2
+ igcmod=0                  igbmod=0                  diomod=1
+ rdsmod=1                  rbodymod=0                rgeomod=1
+ rgatemod=1*rgflag_hv18_snw_spw                      permod=1
+ acnqsmod=0                trnqsmod=0                tempmod=0
+ tnom=25                   toxe=toxp_hv18_spw        toxm=3.85e-009
+ dtox=3.8e-010             epsrox=3.9                wint=0
+ lint=1.221e-007           ll=0                      wl=0
+ lln=1                     wln=1                     lw=0
+ ww=0                      lwn=1                     wwn=1
+ lwl=0                     wwl=0                     llc=0
+ wlc=0                     lwc=0                     wwc=0
+ lwlc=0                    wwlc=0                    xl=1e-08+dxlp_hv18_spw
+ xw=0+dxwp_hv18_spw        dlc=ddlcp_hv18_spw        dwc=0
+ xpart=1                   toxref=3e-009             dlcig=2.5e-009
+ vth0=-0.44594015+dvthp_hv18_spw                     lvth0=7.9606084e-009+dlvthp_hv18_spw
+ wvth0=-6.3354471e-009+dwvthp_hv18_spw               pvth0=-9.7222361e-016+dpvthp_hv18_spw
+ k1=0.332                  k2=0.02926123+dk2p_hv18_spw
+ lk2=1.1882742e-008+dlk2p_hv18_spw                   wk2=2.7123517e-010+dwk2p_hv18_spw
+ pk2=-4.9633299e-015+dpk2p_hv18_spw                  k3=-2.3465
+ k3b=1                     w0=0                      dvt0=0.75418
+ dvt1=0.034455             dvt2=0                    dvt0w=0
+ dvt1w=0                   dvt2w=0                   dsub=0.4
+ minv=-0.2983166           lminv=-3.3238414e-011     wminv=-1.0210553e-011
+ pminv=9.9715242e-017      voffl=-5e-009             dvtp0=2.5e-007
+ dvtp1=0.08                lpe0=1.4918e-007          lpeb=7.0022e-008
+ xj=8.5e-008               ngate=2.092e+020          ndep=6e+017
+ nsd=1e+020                phin=0.174                cdsc=0
+ cdscb=0                   cdscd=0                   cit=0.0001918671+dcitp_hv18_spw
+ lcit=2.6522174e-10+dlcitp_hv18_spw                  wcit=7.5365184e-10+dwcitp_hv18_spw
+ pcit=-1.436272e-16+dpcitp_hv18_spw                  voff=-0.11766217+dvoffp_hv18_spw
+ lvoff=2.2336213e-08+dlvoffp_hv18_spw                wvoff=3.3894227e-09+dwvoffp_hv18_spw
+ pvoff=-1.1566967e-14+dpvoffp_hv18_spw               nfactor=0.7+dnfactorp_hv18_spw
+ eta0=0.028556+deta0p_hv18_spw                       etab=-1.4766124
+ wetab=1.0786124e-006      ud=0                      lud=0
+ wud=0                     pud=0                     u0=0.011842826+du0p_hv18_spw
+ lu0=2.9955996e-010+dlu0p_hv18_spw                   wu0=1.9152483e-010+dwu0p_hv18_spw
+ pu0=1.6577784e-016+dpu0p_hv18_spw                   ua=5.6470586e-010
+ lua=-1.8758955e-017       wua=-1.1999372e-016       pua=4.0222686e-023
+ ub=1.1407297e-018         lub=-3.1052972e-026       wub=4.6995109e-026
+ pub=-1.0298102e-031       uc=3.1304468e-011         luc=5.5859582e-018
+ wuc=-5.7640169e-018       puc=-1.1254756e-023       vsat=160000+dvsatp_hv18_spw
+ a0=2.4912148+da0p_hv18_spw                          la0=-8.0191891e-007+dla0p_hv18_spw
+ wa0=-2.0612601e-007+dwa0p_hv18_spw                  pa0=-2.9042189e-014+dpa0p_hv18_spw
+ ags=0.5836603+dagsp_hv18_spw+0.00425443*ff_flag_hv18_snw_spw-3.3e-07*ss_flag_hv18_snw_spw
+ lags=1.725575e-007+dlagsp_hv18_spw-4.15481e-08*ff_flag_hv18_snw_spw+4e-12*ss_flag_hv18_snw_spw
+ wags=-7.0964657e-008+dwagsp_hv18_spw-3.829e-08*ff_flag_hv18_snw_spw+1.27633e-07*ss_flag_hv18_snw_spw
+ pags=8.5106909e-014+dpagsp_hv18_spw+3.73932e-13*ff_flag_hv18_snw_spw-1.24644e-12*ss_flag_hv18_snw_spw
+ a1=0                      a2=1                      b0=0
+ b1=0                      keta=-0.042496477         lketa=-4.7882045e-008
+ wketa=3.7460168e-009      pketa=9.047913e-015       dwg=0
+ dwb=0                     pclm=0.33911274           lpclm=2.077405e-08
+ wpclm=6.3816504e-09       ppclm=-6.2322068e-14      pdiblc1=0
+ pdiblc2=0.0001            pdiblcb=0                 drout=0.56
+ pvag=0                    delta=0.01                pscbe1=9.264e+008
+ pscbe2=1e-020             fprout=50                 pdits=0
+ pditsd=0                  rsh=15.2                  rsw=169.8
+ rdw=1980.2                prwg=0                    prwb=0
+ wr=1                      alpha0=1.5106e-08         alpha1=0.024473
+ beta0=30                  agidl=1e-007+dagidlp_hv18_spw
+ bgidl=9e+009+dbgidlp_hv18_spw                       cgidl=10
+ egidl=0.902               aigbacc=0.01238           bigbacc=0.006109
+ cigbacc=0.2809            nigbacc=4.05              aigbinv=0.35
+ bigbinv=0.03              cigbinv=0.006             eigbinv=1.1
+ nigbinv=1                 aigc=0.009898             bigc=0.001383
+ cigc=1.515e-005           aigsd=0.0086              bigsd=0.0004353
+ cigsd=3.925e-020          nigc=1                    poxedge=1
+ pigcd=1.672               ntox=1                    xrcrg1=12
+ xrcrg2=1                  cgso=cgsop_hv18_spw       cgdo=cgdop_hv18_spw
+ cgbo=0                    cgdl=cgdlp_hv18_spw       cgsl=cgslp_hv18_spw
+ clc=1e-007                cle=0.6                   cf=cfp_hv18_spw
+ ckappas=0.6               ckappad=0.6               acde=0.4
+ moin=6.5786               noff=2.289                voffcv=-0.0744
+ tvoff=0.0015              ltvoff=0                  wtvoff=0
+ ptvoff=0                  kt1=-0.23359136+dkt1p_hv18_spw
+ lkt1=-3.7438918e-008+dlkt1p_hv18_spw                wkt1=2.6334886e-008+dwkt1p_hv18_spw
+ pkt1=-1.4745391e-014+dpkt1p_hv18_spw                kt1l=0
+ kt2=-0.042984375          lkt2=-8.7612317e-009      wkt2=1.3667693e-008
+ pkt2=1.9805952e-015       ute=-0.97447362           lute=-2.492881e-007
+ ua1=1.217421e-009         lua1=2.1796507e-016       wua1=-4.2308989e-016
+ pua1=-1.095746e-022       ub1=-9.6701676e-019       lub1=-1.448383e-024
+ wub1=5.8995064e-025       pub1=4.9187284e-031       uc1=9.8636753e-011
+ luc1=2.6831676e-018       wuc1=-3.8178322e-017      puc1=-1.5056977e-024
+ prt=0                     at=14464.95+datp_hv18_spw lat=-0.14126326+dlatp_hv18_spw
+ wat=0.0025526383+dwatp_hv18_spw                     pat=-2.492881e-008+dpatp_hv18_spw
+ jss=1.67e-007             jsws=4.74e-013            jswgs=4.74e-013
+ njs=1.02                  njd=1.02                  ijthsfwd=0.01
+ ijthdfwd=0.01             ijthsrev=0.01             ijthdrev=0.01
+ bvs=8.2                   xjbvs=1                   xjbvd=1
+ jsd=1.57e-007             jswd=4.56e-013            jswgd=4.56e-013
+ bvd=14.2                  jtsswgs=1e-009+djtsswgsp_hv18_spw
+ jtsswgd=5e-008+djtsswgdp_hv18_spw                   njtsswg=8+dnjtsswgp_hv18_spw
+ xtsswgs=0.1               xtsswgd=0.45              tnjtsswg=1
+ vtsswgs=0.6               vtsswgd=0.1               pbs=0.5
+ cjs=cjsp_hv18_spw         mjs=0.24                  pbsws=0.9
+ cjsws=cjswsp_hv18_spw     mjsws=0.02                pbswgs=0.5
+ cjswgs=cjswgsp_hv18_spw   mjswgs=0.7                pbd=0.6
+ cjd=cjdp_hv18_spw         mjd=0.31                  pbswd=0.7
+ cjswd=cjswdp_hv18_spw     mjswd=0.35                pbswgd=0.8
+ cjswgd=cjswgdp_hv18_spw   mjswgd=0.43               tpb=0.00155
+ tcj=0.0011                tpbsw=0.0018              tcjsw=0.0011
+ tpbswg=0.0018             tcjswg=0.00118            xtis=3
+ xtid=3                    dmcg=6.4e-08              dmci=6.4e-08
+ dmdg=0                    dmcgt=0                   dwj=0
+ xgw=0                     xgl=-8.2e-09              rshg=14.1
+ gbmin=1e-012              rbpb=50                   rbpd=50
+ rbps=50                   rbdb=50                   rbsb=50
+ ngcon=1                   lvsat=0+dlvsatp_hv18_spw  wnfactor=0+dwnfactorp_hv18_spw
+ lnfactor=0+dlnfactorp_hv18_spw                      pnfactor=0+dpnfactorp_hv18_spw
+ pvsat=0+dpvsatp_hv18_spw  wvsat=0+dwvsatp_hv18_spw  weta0=0+dweta0p_hv18_spw
+ lagidl=0+dlagidlp_hv18_spw                          wagidl=0+dwagidlp_hv18_spw
+ pagidl=0+dpagidlp_hv18_spw                          lbgidl=0+dlbgidlp_hv18_spw
+ wbgidl=0+dwbgidlp_hv18_spw                          pbgidl=0+dpbgidlp_hv18_spw
+ minr=1e-3

     18: type=p
+ lmin=8e-007-dxlp_hv18_spw lmax=1e-006-dxlp_hv18_spw wmin=0.6e-06
+ wmax=1e-006-dxwp_hv18_spw version=4.5               binunit=2
+ paramchk=1                mobmod=0                  capmod=2
+ igcmod=0                  igbmod=0                  diomod=1
+ rdsmod=1                  rbodymod=0                rgeomod=1
+ rgatemod=1*rgflag_hv18_snw_spw                      permod=1
+ acnqsmod=0                trnqsmod=0                tempmod=0
+ tnom=25                   toxe=toxp_hv18_spw        toxm=3.85e-009
+ dtox=3.8e-010             epsrox=3.9                wint=0
+ lint=1.221e-007           ll=0                      wl=0
+ lln=1                     wln=1                     lw=0
+ ww=0                      lwn=1                     wwn=1
+ lwl=0                     wwl=0                     llc=0
+ wlc=0                     lwc=0                     wwc=0
+ lwlc=0                    wwlc=0                    xl=1e-08+dxlp_hv18_spw
+ xw=0+dxwp_hv18_spw        dlc=ddlcp_hv18_spw        dwc=0
+ xpart=1                   toxref=3e-009             dlcig=2.5e-009
+ vth0=-0.32562425+dvthp_hv18_spw                     lvth0=-8.4177308e-08+dlvthp_hv18_spw
+ wvth0=-5.3052843e-08+dwvthp_hv18_spw                pvth0=3.4803957e-14+dpvthp_hv18_spw
+ k1=0.332                  k2=0.035773293+dk2p_hv18_spw
+ lk2=6.8958046e-009+dlk2p_hv18_spw                   wk2=5.88087e-010+dwk2p_hv18_spw
+ pk2=-5.205975e-015+dpk2p_hv18_spw                   k3=-2.3465
+ k3b=1                     w0=0                      dvt0=0.75418
+ dvt1=0.034455             dvt2=0                    dvt0w=0
+ dvt1w=0                   dvt2w=0                   dsub=0.4
+ minv=-0.29530468          lminv=-2.3397641e-009     wminv=-2.93532e-009
+ pminv=2.3397641e-015      voffl=-5e-009             dvtp0=2.5e-007
+ dvtp1=0.08                lpe0=1.4918e-007          lpeb=7.0022e-008
+ xj=8.5e-008               ngate=2.092e+020          ndep=6e+017
+ nsd=1e+020                phin=0.174                cdsc=0
+ cdscb=0                   cdscd=0                   cit=0.00065979+dcitp_hv18_spw
+ lcit=-9.311365e-11+dlcitp_hv18_spw                  wcit=6.11421e-10+dwcitp_hv18_spw
+ pcit=-3.470679e-17+dpcitp_hv18_spw                  voff=0.05346422+dvoffp_hv18_spw
+ lvoff=-1.0871237e-07+dlvoffp_hv18_spw               wvoff=-8.674008e-08+dwvoffp_hv18_spw
+ pvoff=5.7454206e-14+dpvoffp_hv18_spw                nfactor=0.7+dnfactorp_hv18_spw
+ eta0=0.028556+deta0p_hv18_spw                       etab=-1.4766124
+ wetab=1.0786124e-006      ud=0                      lud=0
+ wud=0                     pud=0                     u0=0.0074487408+du0p_hv18_spw
+ lu0=3.6645504e-009+dlu0p_hv18_spw                   wu0=1.9823442e-009+dwu0p_hv18_spw
+ pu0=-1.2056317e-015+dpu0p_hv18_spw                  ua=1.0985978e-009
+ lua=-4.2761338e-016       wua=-5.7295548e-016       pua=3.871008e-022
+ ub=-6.1758938e-019        lub=1.3154678e-024        wub=1.0956084e-024
+ pub=-9.0600906e-031       uc=-1.093288e-010         luc=1.1328292e-016
+ wuc=6.9678811e-017        puc=-6.9028874e-023       vsat=160000+dvsatp_hv18_spw
+ a0=4.1147671+da0p_hv18_spw                          la0=-2.0452352e-006+dla0p_hv18_spw
+ wa0=-9.3446762e-007+dwa0p_hv18_spw                  pa0=5.2872181e-013+dpa0p_hv18_spw
+ ags=-2.0843976+dagsp_hv18_spw+0.5158*ff_flag_hv18_snw_spw+0.5657*ss_flag_hv18_snw_spw
+ lags=2.2157562e-006+dlagsp_hv18_spw-4.33292e-07*ff_flag_hv18_snw_spw-4.33249e-07*ss_flag_hv18_snw_spw
+ wags=1.3254408e-006+dwagsp_hv18_spw-3.987e-07*ff_flag_hv18_snw_spw-6.513e-07*ss_flag_hv18_snw_spw
+ pags=-9.8426039e-013+dpagsp_hv18_spw+6.49932e-13*ff_flag_hv18_snw_spw-6.49941e-13*ss_flag_hv18_snw_spw
+ a1=0                      a2=1                      b0=0
+ b1=0                      keta=-0.054050487         lketa=-3.9033984e-008
+ wketa=3.7350776e-010      pketa=1.163058e-014       dwg=0
+ dwb=0                     pclm=0.436965             ppclm=1.6248362e-13
+ wpclm=-2.87175e-07        lpclm=-5.416121e-08       pdiblc1=0
+ pdiblc2=0.0001            pdiblcb=0                 drout=0.56
+ pvag=0                    delta=0.01                pscbe1=9.264e+008
+ pscbe2=1e-020             fprout=50                 pdits=0
+ pditsd=0                  rsh=15.2                  rsw=169.8
+ rdw=1980.2                prwg=0                    prwb=0
+ wr=1                      alpha0=1.5106e-08         alpha1=0.024473
+ beta0=30                  agidl=1e-007+dagidlp_hv18_spw
+ bgidl=9e+009+dbgidlp_hv18_spw                       cgidl=10
+ egidl=0.902               aigbacc=0.01238           bigbacc=0.006109
+ cigbacc=0.2809            nigbacc=4.05              aigbinv=0.35
+ bigbinv=0.03              cigbinv=0.006             eigbinv=1.1
+ nigbinv=1                 aigc=0.009898             bigc=0.001383
+ cigc=1.515e-005           aigsd=0.0086              bigsd=0.0004353
+ cigsd=3.925e-020          nigc=1                    poxedge=1
+ pigcd=1.672               ntox=1                    xrcrg1=12
+ xrcrg2=1                  cgso=cgsop_hv18_spw       cgdo=cgdop_hv18_spw
+ cgbo=0                    cgdl=cgdlp_hv18_spw       cgsl=cgslp_hv18_spw
+ clc=1e-007                cle=0.6                   cf=cfp_hv18_spw
+ ckappas=0.6               ckappad=0.6               acde=0.4
+ moin=6.5786               noff=2.289                voffcv=-0.0744
+ tvoff=0.0015              ltvoff=0                  wtvoff=0
+ ptvoff=0                  kt1=-0.22424503+dkt1p_hv18_spw
+ lkt1=-4.4596336e-008+dlkt1p_hv18_spw                wkt1=-1.5792465e-008+dwkt1p_hv18_spw
+ pkt1=1.7515734e-014+dpkt1p_hv18_spw                 kt1l=0
+ kt2=-0.093506222          lkt2=2.9928399e-008       wkt2=5.2260099e-008
+ pkt2=-2.7573469e-014      ute=-1.3                  ua1=-4.7337424e-010
+ lua1=1.5127761e-015       wua1=2.6228305e-016       pua1=-6.344332e-022
+ ub1=-1.3659106e-018       lub1=-1.1429101e-024      wub1=1.4100522e-024
+ pub1=-1.3616091e-031      uc1=3.3487527e-010        luc1=-1.7822829e-016
+ wuc1=-1.9217639e-016      puc1=1.1642603e-022       prt=0
+ at=-28550.071+datp_hv18_spw                         lat=-0.10832236+dlatp_hv18_spw
+ wat=-0.11486996+dwatp_hv18_spw                      pat=6.4993413e-008+dpatp_hv18_spw
+ jss=1.67e-007             jsws=4.74e-013            jswgs=4.74e-013
+ njs=1.02                  njd=1.02                  ijthsfwd=0.01
+ ijthdfwd=0.01             ijthsrev=0.01             ijthdrev=0.01
+ bvs=8.2                   xjbvs=1                   xjbvd=1
+ jsd=1.57e-007             jswd=4.56e-013            jswgd=4.56e-013
+ bvd=14.2                  jtsswgs=1e-009+djtsswgsp_hv18_spw
+ jtsswgd=5e-008+djtsswgdp_hv18_spw                   njtsswg=8+dnjtsswgp_hv18_spw
+ xtsswgs=0.1               xtsswgd=0.45              tnjtsswg=1
+ vtsswgs=0.6               vtsswgd=0.1               pbs=0.5
+ cjs=cjsp_hv18_spw         mjs=0.24                  pbsws=0.9
+ cjsws=cjswsp_hv18_spw     mjsws=0.02                pbswgs=0.5
+ cjswgs=cjswgsp_hv18_spw   mjswgs=0.7                pbd=0.6
+ cjd=cjdp_hv18_spw         mjd=0.31                  pbswd=0.7
+ cjswd=cjswdp_hv18_spw     mjswd=0.35                pbswgd=0.8
+ cjswgd=cjswgdp_hv18_spw   mjswgd=0.43               tpb=0.00155
+ tcj=0.0011                tpbsw=0.0018              tcjsw=0.0011
+ tpbswg=0.0018             tcjswg=0.00118            xtis=3
+ xtid=3                    dmcg=6.4e-08              dmci=6.4e-08
+ dmdg=0                    dmcgt=0                   dwj=0
+ xgw=0                     xgl=-8.2e-09              rshg=14.1
+ gbmin=1e-012              rbpb=50                   rbpd=50
+ rbps=50                   rbdb=50                   rbsb=50
+ ngcon=1                   lvsat=0+dlvsatp_hv18_spw  wnfactor=0+dwnfactorp_hv18_spw
+ lnfactor=0+dlnfactorp_hv18_spw                      pnfactor=0+dpnfactorp_hv18_spw
+ pvsat=0+dpvsatp_hv18_spw  wvsat=0+dwvsatp_hv18_spw  weta0=0+dweta0p_hv18_spw
+ lagidl=0+dlagidlp_hv18_spw                          wagidl=0+dwagidlp_hv18_spw
+ pagidl=0+dpagidlp_hv18_spw                          lbgidl=0+dlbgidlp_hv18_spw
+ wbgidl=0+dwbgidlp_hv18_spw                          pbgidl=0+dpbgidlp_hv18_spw
+ minr=1e-3

     19: type=p
+ lmin=7e-007-dxlp_hv18_spw lmax=8e-007-dxlp_hv18_spw wmin=0.6e-06
+ wmax=1e-006-dxwp_hv18_spw version=4.5               binunit=2
+ paramchk=1                mobmod=0                  capmod=2
+ igcmod=0                  igbmod=0                  diomod=1
+ rdsmod=1                  rbodymod=0                rgeomod=1
+ rgatemod=1*rgflag_hv18_snw_spw                      permod=1
+ acnqsmod=0                trnqsmod=0                tempmod=0
+ tnom=25                   toxe=toxp_hv18_spw        toxm=3.85e-009
+ dtox=3.8e-010             epsrox=3.9                wint=0
+ lint=1.221e-007           ll=0                      wl=0
+ lln=1                     wln=1                     lw=0
+ ww=0                      lwn=1                     wwn=1
+ lwl=0                     wwl=0                     llc=0
+ wlc=0                     lwc=0                     wwc=0
+ lwlc=0                    wwlc=0                    xl=1e-08+dxlp_hv18_spw
+ xw=0+dxwp_hv18_spw        dlc=ddlcp_hv18_spw        dwc=0
+ xpart=1                   toxref=3e-009             dlcig=2.5e-009
+ vth0=-0.46429212+dvthp_hv18_spw                     lvth0=-5.7190268e-09+dlvthp_hv18_spw
+ wvth0=2.730645e-09+dwvthp_hv18_spw                  pvth0=3.2416608e-15+dpvthp_hv18_spw
+ k1=0.332                  k2=0.018652843+dk2p_hv18_spw
+ lk2=1.6582555e-008+dlk2p_hv18_spw                   wk2=1.4597835e-008+dwk2p_hv18_spw
+ pk2=-1.313269e-014+dpk2p_hv18_spw                   k3=-2.3465
+ k3b=1                     w0=0                      dvt0=0.75418
+ dvt1=0.034455             dvt2=0                    dvt0w=0
+ dvt1w=0                   dvt2w=0                   dsub=0.4
+ minv=-0.30465696          lminv=2.951756e-009       wminv=6.7896e-009
+ pminv=-3.1625957e-015     voffl=-5e-009             dvtp0=2.5e-007
+ dvtp1=0.08                lpe0=1.4918e-007          lpeb=7.0022e-008
+ xj=8.5e-008               ngate=2.092e+020          ndep=6e+017
+ nsd=1e+020                phin=0.174                cdsc=0
+ cdscb=0                   cdscd=0                   cit=-0.00038388349+dcitp_hv18_spw
+ lcit=4.9739684e-10+dlcitp_hv18_spw                  wcit=1.4976561e-09+dwcitp_hv18_spw
+ pcit=-5.3613864e-16+dpcitp_hv18_spw                 voff=-0.15693424+dvoffp_hv18_spw
+ lvoff=1.033108e-008+dlvoffp_hv18_spw                wvoff=3.353009e-008+dwvoffp_hv18_spw
+ pvoff=-1.0594656e-014+dpvoffp_hv18_spw              nfactor=0.7+dnfactorp_hv18_spw
+ eta0=0.028556+deta0p_hv18_spw                       etab=-1.4766124
+ wetab=1.0786124e-006      ud=0                      lud=0
+ wud=0                     pud=0                     u0=0.019519758+du0p_hv18_spw
+ lu0=-3.1652312e-009+dlu0p_hv18_spw                  wu0=-2.607924e-009+dwu0p_hv18_spw
+ pu0=1.3915421e-015+dpu0p_hv18_spw                   ua=2.386434e-009
+ lua=-1.1562711e-015       wua=-8.9729321e-016       pua=5.7061109e-022
+ ub=1.5486129e-018         lub=8.9830539e-026        wub=-1.9972006e-025
+ pub=-1.7311222e-031       uc=1.338091e-010          luc=-2.428451e-017
+ wuc=-5.1286555e-017       puc=-5.866698e-025        vsat=160000+dvsatp_hv18_spw
+ a0=0.73290007+da0p_hv18_spw                         la0=-1.3177486e-007+dla0p_hv18_spw
+ wa0=6.9870027e-007+dwa0p_hv18_spw                   pa0=-3.9532458e-013+dpa0p_hv18_spw
+ ags=-2.1147411+dagsp_hv18_spw-0.9487*ff_flag_hv18_snw_spw-0.6658*ss_flag_hv18_snw_spw
+ lags=2.2329246e-006+dlagsp_hv18_spw+3.95322e-07*ff_flag_hv18_snw_spw+2.63558e-07*ss_flag_hv18_snw_spw
+ wags=5.7171585e-007+dwagsp_hv18_spw+2.8461e-06*ff_flag_hv18_snw_spw-1.8e-06*ss_flag_hv18_snw_spw
+ pags=-5.5780281e-013+dpagsp_hv18_spw-1.18597e-12*ff_flag_hv18_snw_spw+4.23e-17*ss_flag_hv18_snw_spw
+ a1=0                      a2=1                      b0=0
+ b1=0                      keta=-0.050234974         lketa=-4.1192801e-008
+ wketa=-1.0931206e-008     pketa=1.8026787e-014      dwg=0
+ dwb=0                     pclm=1.1011464            lpclm=-4.2995504e-007
+ wpclm=-7.599064e-007      ppclm=4.2995504e-013      pdiblc1=0
+ pdiblc2=0.0001            pdiblcb=0                 drout=0.56
+ pvag=0                    delta=0.01                pscbe1=9.264e+008
+ pscbe2=1e-020             fprout=50                 pdits=0
+ pditsd=0                  rsh=15.2                  rsw=169.8
+ rdw=1980.2                prwg=0                    prwb=0
+ wr=1                      alpha0=1.5106e-08         alpha1=0.024473
+ beta0=30                  agidl=1e-007+dagidlp_hv18_spw
+ bgidl=9e+009+dbgidlp_hv18_spw                       cgidl=10
+ egidl=0.902               aigbacc=0.01238           bigbacc=0.006109
+ cigbacc=0.2809            nigbacc=4.05              aigbinv=0.35
+ bigbinv=0.03              cigbinv=0.006             eigbinv=1.1
+ nigbinv=1                 aigc=0.009898             bigc=0.001383
+ cigc=1.515e-005           aigsd=0.0086              bigsd=0.0004353
+ cigsd=3.925e-020          nigc=1                    poxedge=1
+ pigcd=1.672               ntox=1                    xrcrg1=12
+ xrcrg2=1                  cgso=cgsop_hv18_spw       cgdo=cgdop_hv18_spw
+ cgbo=0                    cgdl=cgdlp_hv18_spw       cgsl=cgslp_hv18_spw
+ clc=1e-007                cle=0.6                   cf=cfp_hv18_spw
+ ckappas=0.6               ckappad=0.6               acde=0.4
+ moin=6.5786               noff=2.289                voffcv=-0.0744
+ tvoff=0.0015              ltvoff=0                  wtvoff=0
+ ptvoff=0                  kt1=-0.23939028+dkt1p_hv18_spw
+ lkt1=-3.6027157e-008+dlkt1p_hv18_spw                wkt1=-3.402334e-008+dwkt1p_hv18_spw
+ pkt1=2.7830763e-014+dpkt1p_hv18_spw                 kt1l=0
+ kt2=0.080674498           lkt2=-6.8623053e-008      wkt2=-8.8757794e-008
+ pkt2=5.2214455e-014       ute=-1.3                  ua1=-5.960921e-010
+ lua1=1.5822098e-015       wua1=2.6971118e-015       pua1=-2.0120593e-021
+ ub1=-2.4834893e-019       lub1=-1.7752265e-024      wub1=-4.6031817e-024
+ pub1=3.2661268e-030       uc1=-6.8855994e-010       luc1=4.0083135e-016
+ wuc1=3.6391724e-016       puc1=-1.9821176e-022      prt=0
+ at=-359739.67+datp_hv18_spw                         lat=0.079064721+dlatp_hv18_spw
+ wat=0.27947977+dwatp_hv18_spw                       pat=-1.5812966e-007+dpatp_hv18_spw
+ jss=1.67e-007             jsws=4.74e-013            jswgs=4.74e-013
+ njs=1.02                  njd=1.02                  ijthsfwd=0.01
+ ijthdfwd=0.01             ijthsrev=0.01             ijthdrev=0.01
+ bvs=8.2                   xjbvs=1                   xjbvd=1
+ jsd=1.57e-007             jswd=4.56e-013            jswgd=4.56e-013
+ bvd=14.2                  jtsswgs=1e-009+djtsswgsp_hv18_spw
+ jtsswgd=5e-008+djtsswgdp_hv18_spw                   njtsswg=8+dnjtsswgp_hv18_spw
+ xtsswgs=0.1               xtsswgd=0.45              tnjtsswg=1
+ vtsswgs=0.6               vtsswgd=0.1               pbs=0.5
+ cjs=cjsp_hv18_spw         mjs=0.24                  pbsws=0.9
+ cjsws=cjswsp_hv18_spw     mjsws=0.02                pbswgs=0.5
+ cjswgs=cjswgsp_hv18_spw   mjswgs=0.7                pbd=0.6
+ cjd=cjdp_hv18_spw         mjd=0.31                  pbswd=0.7
+ cjswd=cjswdp_hv18_spw     mjswd=0.35                pbswgd=0.8
+ cjswgd=cjswgdp_hv18_spw   mjswgd=0.43               tpb=0.00155
+ tcj=0.0011                tpbsw=0.0018              tcjsw=0.0011
+ tpbswg=0.0018             tcjswg=0.00118            xtis=3
+ xtid=3                    dmcg=6.4e-08              dmci=6.4e-08
+ dmdg=0                    dmcgt=0                   dwj=0
+ xgw=0                     xgl=-8.2e-09              rshg=14.1
+ gbmin=1e-012              rbpb=50                   rbpd=50
+ rbps=50                   rbdb=50                   rbsb=50
+ ngcon=1                   lvsat=0+dlvsatp_hv18_spw  wnfactor=0+dwnfactorp_hv18_spw
+ lnfactor=0+dlnfactorp_hv18_spw                      pnfactor=0+dpnfactorp_hv18_spw
+ pvsat=0+dpvsatp_hv18_spw  wvsat=0+dwvsatp_hv18_spw  weta0=0+dweta0p_hv18_spw
+ lagidl=0+dlagidlp_hv18_spw                          wagidl=0+dwagidlp_hv18_spw
+ pagidl=0+dpagidlp_hv18_spw                          lbgidl=0+dlbgidlp_hv18_spw
+ wbgidl=0+dwbgidlp_hv18_spw                          pbgidl=0+dpbgidlp_hv18_spw
+ minr=1e-3

     20: type=p
+ lmin=0.594e-06            lmax=7e-007-dxlp_hv18_spw wmin=0.6e-06
+ wmax=1e-006-dxwp_hv18_spw version=4.5               binunit=2
+ paramchk=1                mobmod=0                  capmod=2
+ igcmod=0                  igbmod=0                  diomod=1
+ rdsmod=1                  rbodymod=0                rgeomod=1
+ rgatemod=1*rgflag_hv18_snw_spw                      permod=1
+ acnqsmod=0                trnqsmod=0                tempmod=0
+ tnom=25                   toxe=toxp_hv18_spw        toxm=3.85e-009
+ dtox=3.8e-010             epsrox=3.9                wint=0
+ lint=1.221e-007           ll=0                      wl=0
+ lln=1                     wln=1                     lw=0
+ ww=0                      lwn=1                     wwn=1
+ lwl=0                     wwl=0                     llc=0
+ wlc=0                     lwc=0                     wwc=0
+ lwlc=0                    wwlc=0                    xl=1e-08+dxlp_hv18_spw
+ xw=0+dxwp_hv18_spw        dlc=ddlcp_hv18_spw        dwc=0
+ xpart=1                   toxref=3e-009             dlcig=2.5e-009
+ vth0=-0.69603295+dvthp_hv18_spw                     lvth0=1.0222586e-07+dlvthp_hv18_spw
+ wvth0=1.5844239e-07+dwvthp_hv18_spw                 pvth0=-6.9288871e-14+dpvthp_hv18_spw
+ k1=0.332                  k2=0.16656452+dk2p_hv18_spw
+ lk2=-5.2314706e-008+dlk2p_hv18_spw                  wk2=-9.2872126e-008+dwk2p_hv18_spw
+ pk2=3.6926817e-014+dpk2p_hv18_spw                   k3=-2.3465
+ k3b=1                     w0=0                      dvt0=0.75418
+ dvt1=0.034455             dvt2=0                    dvt0w=0
+ dvt1w=0                   dvt2w=0                   dsub=0.4
+ minv=-0.29832             voffl=-5e-009             dvtp0=2.5e-007
+ dvtp1=0.08                lpe0=1.4918e-007          lpeb=7.0022e-008
+ xj=8.5e-008               ngate=2.092e+020          ndep=6e+017
+ nsd=1e+020                phin=0.174                cdsc=0
+ cdscb=0                   cdscd=0                   cit=0.0023139589+dcitp_hv18_spw
+ lcit=-7.5925809e-10+dlcitp_hv18_spw                 wcit=-9.3811694e-10+dwcitp_hv18_spw
+ pcit=5.9844442e-16+dpcitp_hv18_spw                  voff=-0.35856976+dvoffp_hv18_spw
+ lvoff=1.042529e-007+dlvoffp_hv18_spw                wvoff=1.3785292e-007+dwvoffp_hv18_spw
+ pvoff=-5.9188231e-014+dpvoffp_hv18_spw              nfactor=0.7+dnfactorp_hv18_spw
+ eta0=0.028556+deta0p_hv18_spw                       etab=-1.4766124
+ wetab=1.0786124e-006      ud=0                      lud=0
+ wud=0                     pud=0                     u0=0.02428378+du0p_hv18_spw
+ lu0=-5.3843126e-009+dlu0p_hv18_spw                  wu0=-1.1702874e-008+dwu0p_hv18_spw
+ pu0=5.6279698e-015+dpu0p_hv18_spw                   ua=-7.1633233e-010
+ lua=2.8899744e-016        wua=9.159255e-016         pua=-2.7398618e-022
+ ub=5.365864e-018          lub=-1.6882451e-024       wub=-3.9931116e-024
+ pub=1.5938495e-030        uc=4.915614e-010          luc=-1.9092553e-016
+ wuc=-3.7038823e-016       puc=1.4805089e-022        vsat=160000+dvsatp_hv18_spw
+ a0=1.4559501+da0p_hv18_spw-0.82305*ff_flag_hv18_snw_spw+0.0*ss_flag_hv18_snw_spw
+ la0=-4.6857155e-007+dla0p_hv18_spw+3.83377e-07*ff_flag_hv18_snw_spw+5e-14*ss_flag_hv18_snw_spw
+ wa0=-4.2434993e-007+dwa0p_hv18_spw+4.9383e-07*ff_flag_hv18_snw_spw+0.0*ss_flag_hv18_snw_spw
+ pa0=1.277922e-013+dpa0p_hv18_spw-2.30026e-13*ff_flag_hv18_snw_spw-2.3e-19*ss_flag_hv18_snw_spw
+ ags=-10.794886+dagsp_hv18_spw-0.4658*ff_flag_hv18_snw_spw+8.6792*ss_flag_hv18_snw_spw
+ lags=6.2761362e-06+dlagsp_hv18_spw+1.70388e-07*ff_flag_hv18_snw_spw-4.08935e-06*ss_flag_hv18_snw_spw
+ wags=2.7869003e-06+dwagsp_hv18_spw+1.3974e-06*ff_flag_hv18_snw_spw-1.38714e-05*ss_flag_hv18_snw_spw
+ pags=-1.5896357e-12+dpagsp_hv18_spw-5.11168e-13*ff_flag_hv18_snw_spw+5.62286e-12*ss_flag_hv18_snw_spw
+ a1=0                      a2=1                      b0=0
+ b1=0                      keta=-0.24286579          lketa=4.8534632e-008
+ wketa=1.4257399e-007      pketa=-5.3475931e-014     dwg=0
+ dwb=0                     pclm=-0.22665787          lpclm=1.8853619e-007
+ wpclm=1.8651479e-007      ppclm=-1.0887949e-014     pdiblc1=0
+ pdiblc2=0.0001            pdiblcb=0                 drout=0.56
+ pvag=0                    delta=0.01                pscbe1=9.264e+008
+ pscbe2=1e-020             fprout=50                 pdits=0
+ pditsd=0                  rsh=15.2                  rsw=169.8
+ rdw=1980.2                prwg=0                    prwb=0
+ wr=1                      alpha0=1.5106e-08         alpha1=0.024473
+ beta0=30                  agidl=1e-007+dagidlp_hv18_spw
+ bgidl=9e+009+dbgidlp_hv18_spw                       cgidl=10
+ egidl=0.902               aigbacc=0.01238           bigbacc=0.006109
+ cigbacc=0.2809            nigbacc=4.05              aigbinv=0.35
+ bigbinv=0.03              cigbinv=0.006             eigbinv=1.1
+ nigbinv=1                 aigc=0.009898             bigc=0.001383
+ cigc=1.515e-005           aigsd=0.0086              bigsd=0.0004353
+ cigsd=3.925e-020          nigc=1                    poxedge=1
+ pigcd=1.672               ntox=1                    xrcrg1=12
+ xrcrg2=1                  cgso=cgsop_hv18_spw       cgdo=cgdop_hv18_spw
+ cgbo=0                    cgdl=cgdlp_hv18_spw       cgsl=cgslp_hv18_spw
+ clc=1e-007                cle=0.6                   cf=cfp_hv18_spw
+ ckappas=0.6               ckappad=0.6               acde=0.4
+ moin=6.5786               noff=2.289                voffcv=-0.0744
+ tvoff=0.0015              ltvoff=0                  wtvoff=0
+ ptvoff=0                  kt1=-0.32322781+dkt1p_hv18_spw
+ lkt1=3.024365e-009+dlkt1p_hv18_spw                  wkt1=5.332447e-008+dwkt1p_hv18_spw
+ pkt1=-1.2855847e-014+dpkt1p_hv18_spw                kt1l=0
+ kt2=-0.029777642          lkt2=-1.7174446e-008      wkt2=1.0877503e-008
+ pkt2=5.8043333e-015       ute=-1.3                  ua1=1.0367845e-008
+ lua1=-3.5247922e-015      wua1=-9.3297473e-015      pua1=3.5900516e-021
+ ub1=-1.4796571e-017       lub1=5.0013353e-024       wub1=1.3345864e-023
+ pub1=-5.0945384e-030      uc1=6.2162333e-011        luc1=5.1144918e-017
+ wuc1=2.0193345e-016       puc1=-1.2275971e-022      prt=0
+ at=-190000.19+datp_hv18_spw                         lat=6.8155857e-008+dlatp_hv18_spw
+ wat=-0.05999986+dwatp_hv18_spw                      pat=-5.1116891e-014+dpatp_hv18_spw
+ jss=1.67e-007             jsws=4.74e-013            jswgs=4.74e-013
+ njs=1.02                  njd=1.02                  ijthsfwd=0.01
+ ijthdfwd=0.01             ijthsrev=0.01             ijthdrev=0.01
+ bvs=8.2                   xjbvs=1                   xjbvd=1
+ jsd=1.57e-007             jswd=4.56e-013            jswgd=4.56e-013
+ bvd=14.2                  jtsswgs=1e-009+djtsswgsp_hv18_spw
+ jtsswgd=5e-008+djtsswgdp_hv18_spw                   njtsswg=8+dnjtsswgp_hv18_spw
+ xtsswgs=0.1               xtsswgd=0.45              tnjtsswg=1
+ vtsswgs=0.6               vtsswgd=0.1               pbs=0.5
+ cjs=cjsp_hv18_spw         mjs=0.24                  pbsws=0.9
+ cjsws=cjswsp_hv18_spw     mjsws=0.02                pbswgs=0.5
+ cjswgs=cjswgsp_hv18_spw   mjswgs=0.7                pbd=0.6
+ cjd=cjdp_hv18_spw         mjd=0.31                  pbswd=0.7
+ cjswd=cjswdp_hv18_spw     mjswd=0.35                pbswgd=0.8
+ cjswgd=cjswgdp_hv18_spw   mjswgd=0.43               tpb=0.00155
+ tcj=0.0011                tpbsw=0.0018              tcjsw=0.0011
+ tpbswg=0.0018             tcjswg=0.00118            xtis=3
+ xtid=3                    dmcg=6.4e-08              dmci=6.4e-08
+ dmdg=0                    dmcgt=0                   dwj=0
+ xgw=0                     xgl=-8.2e-09              rshg=14.1
+ gbmin=1e-012              rbpb=50                   rbpd=50
+ rbps=50                   rbdb=50                   rbsb=50
+ ngcon=1                   lvsat=0+dlvsatp_hv18_spw  wnfactor=0+dwnfactorp_hv18_spw
+ lnfactor=0+dlnfactorp_hv18_spw                      pnfactor=0+dpnfactorp_hv18_spw
+ pvsat=0+dpvsatp_hv18_spw  wvsat=0+dwvsatp_hv18_spw  weta0=0+dweta0p_hv18_spw
+ lagidl=0+dlagidlp_hv18_spw                          wagidl=0+dwagidlp_hv18_spw
+ pagidl=0+dpagidlp_hv18_spw                          lbgidl=0+dlbgidlp_hv18_spw
+ wbgidl=0+dwbgidlp_hv18_spw                          pbgidl=0+dpbgidlp_hv18_spw
+ minr=1e-3

     }
endsection mos_hv18_snw_spw
endlibrary tsmclib
