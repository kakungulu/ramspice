//******************************************************************************
//  //             TSMC SPICE MODEL               //
//******************************************************************************
//
//    PROCESS :  40nm Mixed Signal RF SALICIDE ELK IMD (1.1/2.5V) (CRN40LP)
//    MODEL   :  BSIM4 ( V4.5 )
//    DOC. NO.:  T-N40-CM-SP-001
//    VERSION :  v1.3
//    DATE    :	Nov 15, 2010
//    SPECTRE VERSION : 6.2.1.170
//
//***********************************************************************************
//       THIS INCLUDE HEADER CONTAINS :                                             *
//                                                                                  *
//    Total Corner :                                                                *
//	top_tt   totalflag_xx=1 globalflag_xx=1 mismatchflag_xx=1              	    *
//	top_ss   totalflag_xx=1 globalflag_xx=1 mismatchflag_xx=1              	    *
//	top_ff   totalflag_xx=1 globalflag_xx=1 mismatchflag_xx=1              	    *
//	top_fs   totalflag_xx=1 globalflag_xx=1 mismatchflag_xx=1              	    *
//	top_sf   totalflag_xx=1 globalflag_xx=1 mismatchflag_xx=1              	    *
//                                                                                  *
//    Global Corner + Local MC:                                                     *
//	 top_ttg_localmc    totalflag_xx=0 globalflag_xx=1 mismatchflag_xx=1        *
//       top_ssg_localmc    totalflag_xx=0 globalflag_xx=1 mismatchflag_xx=1        *
//       top_ffg_localmc    totalflag_xx=0 globalflag_xx=1 mismatchflag_xx=1        *
//       top_fsg_localmc    totalflag_xx=0 globalflag_xx=1 mismatchflag_xx=1        *
//       top_sfg_localmc    totalflag_xx=0 globalflag_xx=1 mismatchflag_xx=1        *
//                                                                                  *
//    Local MC only:                                                                *
//       top_localmconly    totalflag_xx=0 globalflag_xx=0 mismatchflag_xx=1        *
//    Global MC + Local MC:                                                         *
//       top_globalmc_localmc   totalflag_xx=0 globalflag_xx=1 mismatchflag_xx=1    *
//                                                                                  *
//***********************************************************************************

simulator lang=spectre insensitive=yes

library tsmclib

section top_tt
include "./crn40lp_2d5_v1d3_shrink0d9_embedded_usage.scs" section=ttmacro_mos_moscap
include "./crn40lp_2d5_v1d3_shrink0d9_embedded_usage.scs" section=tt_res_bip_dio_disres
include "./crn40lp_2d5_v1d3_shrink0d9_embedded_usage.scs" section=tt_rtmom
include "./crn40lp_2d5_v1d3_shrink0d9_embedded_usage.scs" section=tt_ind_jvar
include "./cln40lp_hv_2d5_lk_v1d1_1_shrink0d9_embedded_usage.scs" section=tt_hv25
endsection top_tt

section top_ss
include "./crn40lp_2d5_v1d3_shrink0d9_embedded_usage.scs" section=ssmacro_mos_moscap
include "./crn40lp_2d5_v1d3_shrink0d9_embedded_usage.scs" section=ss_res_bip_dio_disres
include "./crn40lp_2d5_v1d3_shrink0d9_embedded_usage.scs" section=ss_rtmom
include "./crn40lp_2d5_v1d3_shrink0d9_embedded_usage.scs" section=ss_ind_jvar
include "./cln40lp_hv_2d5_lk_v1d1_1_shrink0d9_embedded_usage.scs" section=ss_hv25
endsection top_ss

section top_ff
include "./crn40lp_2d5_v1d3_shrink0d9_embedded_usage.scs" section=ffmacro_mos_moscap
include "./crn40lp_2d5_v1d3_shrink0d9_embedded_usage.scs" section=ff_res_bip_dio_disres
include "./crn40lp_2d5_v1d3_shrink0d9_embedded_usage.scs" section=ff_rtmom
include "./crn40lp_2d5_v1d3_shrink0d9_embedded_usage.scs" section=ff_ind_jvar
include "./cln40lp_hv_2d5_lk_v1d1_1_shrink0d9_embedded_usage.scs" section=ff_hv25
endsection top_ff

section top_fs
include "./crn40lp_2d5_v1d3_shrink0d9_embedded_usage.scs" section=fsmacro_mos_moscap
include "./crn40lp_2d5_v1d3_shrink0d9_embedded_usage.scs" section=tt_res_bip_dio_disres
include "./crn40lp_2d5_v1d3_shrink0d9_embedded_usage.scs" section=tt_rtmom
include "./crn40lp_2d5_v1d3_shrink0d9_embedded_usage.scs" section=tt_ind_jvar
include "./cln40lp_hv_2d5_lk_v1d1_1_shrink0d9_embedded_usage.scs" section=fs_hv25
endsection top_fs

section top_sf
include "./crn40lp_2d5_v1d3_shrink0d9_embedded_usage.scs" section=sfmacro_mos_moscap
include "./crn40lp_2d5_v1d3_shrink0d9_embedded_usage.scs" section=tt_res_bip_dio_disres
include "./crn40lp_2d5_v1d3_shrink0d9_embedded_usage.scs" section=tt_rtmom
include "./crn40lp_2d5_v1d3_shrink0d9_embedded_usage.scs" section=tt_ind_jvar
include "./cln40lp_hv_2d5_lk_v1d1_1_shrink0d9_embedded_usage.scs" section=sf_hv25
endsection top_sf

section top_ttg_localmc
include "./crn40lp_2d5_v1d3_shrink0d9_embedded_usage.scs" section=ttglobalcorner_localmc_mos_moscap
include "./crn40lp_2d5_v1d3_shrink0d9_embedded_usage.scs" section=ttglobalcorner_localmc_res_bip_dio_disres
include "./crn40lp_2d5_v1d3_shrink0d9_embedded_usage.scs" section=ttglobalcorner_localmc_rtmom
include "./crn40lp_2d5_v1d3_shrink0d9_embedded_usage.scs" section=ttglobalcorner_localmc_ind_jvar
include "./cln40lp_hv_2d5_lk_v1d1_1_shrink0d9_embedded_usage.scs" section=tt_hv25
endsection top_ttg_localmc

section top_ssg_localmc
include "./crn40lp_2d5_v1d3_shrink0d9_embedded_usage.scs" section=ssglobalcorner_localmc_mos_moscap
include "./crn40lp_2d5_v1d3_shrink0d9_embedded_usage.scs" section=ssglobalcorner_localmc_res_bip_dio_disres
include "./crn40lp_2d5_v1d3_shrink0d9_embedded_usage.scs" section=ssglobalcorner_localmc_rtmom
include "./crn40lp_2d5_v1d3_shrink0d9_embedded_usage.scs" section=ssglobalcorner_localmc_ind_jvar
include "./cln40lp_hv_2d5_lk_v1d1_1_shrink0d9_embedded_usage.scs" section=ss_hv25
endsection top_ssg_localmc

section top_ffg_localmc
include "./crn40lp_2d5_v1d3_shrink0d9_embedded_usage.scs" section=ffglobalcorner_localmc_mos_moscap
include "./crn40lp_2d5_v1d3_shrink0d9_embedded_usage.scs" section=ffglobalcorner_localmc_res_bip_dio_disres
include "./crn40lp_2d5_v1d3_shrink0d9_embedded_usage.scs" section=ffglobalcorner_localmc_rtmom
include "./crn40lp_2d5_v1d3_shrink0d9_embedded_usage.scs" section=ffglobalcorner_localmc_ind_jvar
include "./cln40lp_hv_2d5_lk_v1d1_1_shrink0d9_embedded_usage.scs" section=ff_hv25
endsection top_ffg_localmc

section top_fsg_localmc
include "./crn40lp_2d5_v1d3_shrink0d9_embedded_usage.scs" section=fsglobalcorner_localmc_mos_moscap
include "./crn40lp_2d5_v1d3_shrink0d9_embedded_usage.scs" section=ttglobalcorner_localmc_res_bip_dio_disres
include "./crn40lp_2d5_v1d3_shrink0d9_embedded_usage.scs" section=ttglobalcorner_localmc_rtmom
include "./crn40lp_2d5_v1d3_shrink0d9_embedded_usage.scs" section=ttglobalcorner_localmc_ind_jvar
include "./cln40lp_hv_2d5_lk_v1d1_1_shrink0d9_embedded_usage.scs" section=fs_hv25
endsection top_fsg_localmc

section top_sfg_localmc
include "./crn40lp_2d5_v1d3_shrink0d9_embedded_usage.scs" section=sfglobalcorner_localmc_mos_moscap
include "./crn40lp_2d5_v1d3_shrink0d9_embedded_usage.scs" section=ttglobalcorner_localmc_res_bip_dio_disres
include "./crn40lp_2d5_v1d3_shrink0d9_embedded_usage.scs" section=ttglobalcorner_localmc_rtmom
include "./crn40lp_2d5_v1d3_shrink0d9_embedded_usage.scs" section=ttglobalcorner_localmc_ind_jvar
include "./cln40lp_hv_2d5_lk_v1d1_1_shrink0d9_embedded_usage.scs" section=sf_hv25
endsection top_sfg_localmc

section top_localmconly
include "./crn40lp_2d5_v1d3_shrink0d9_embedded_usage.scs" section=localmconly_mos_moscap
include "./crn40lp_2d5_v1d3_shrink0d9_embedded_usage.scs" section=localmconly_res_bip_dio_disres
include "./crn40lp_2d5_v1d3_shrink0d9_embedded_usage.scs" section=localmconly_rtmom
include "./crn40lp_2d5_v1d3_shrink0d9_embedded_usage.scs" section=localmconly_ind_jvar
include "./cln40lp_hv_2d5_lk_v1d1_1_shrink0d9_embedded_usage.scs" section=tt_hv25
endsection top_localmconly

section top_globalmc_localmc
include "./crn40lp_2d5_v1d3_shrink0d9_embedded_usage.scs" section=globalmc_localmc_mos_moscap
include "./crn40lp_2d5_v1d3_shrink0d9_embedded_usage.scs" section=globalmc_localmc_res_bip_dio_disres
include "./crn40lp_2d5_v1d3_shrink0d9_embedded_usage.scs" section=globalmc_localmc_rtmom
include "./crn40lp_2d5_v1d3_shrink0d9_embedded_usage.scs" section=globalmc_localmc_ind_jvar
include "./cln40lp_hv_2d5_lk_v1d1_1_shrink0d9_embedded_usage.scs" section=tt_hv25
endsection top_globalmc_localmc

section pre_simu
setscale options scalefactor=0.9
parOpt options redefinedparams=ignore
parameters rcoflag_rf=1
parameters ccoflag_rf=1
parameters rcoflag_rf_hvt=1
parameters ccoflag_rf_hvt=1
parameters rcoflag_rf_lvt=1
parameters ccoflag_rf_lvt=1
parameters ccoflag_rf_25ud18=1
parameters rcoflag_rf_25ud18=1
parameters ccoflag_rf_25=1
parameters rcoflag_rf_25=1
parameters ccoflag_rf_25od33=1
parameters rcoflag_rf_25od33=1
parameters ccoflag=1
parameters rcoflag=1
parameters rgflag=1
parameters ccoflag_hvt=1
parameters rgflag_hvt=1
parameters rcoflag_hvt=1
parameters ccoflag_lvt=1
parameters rcoflag_lvt=1
parameters rgflag_lvt=1
parameters ccoflag_25=1
parameters rgflag_25=1
parameters rcoflag_25=1
parameters ccoflag_25ud18=1
parameters rgflag_25ud18=1
parameters rcoflag_25ud18=1
parameters ccoflag_25od33=1
parameters rgflag_25od33=1
parameters rcoflag_25od33=1
parameters ccoflag_na=1
parameters rgflag_na=1
parameters rcoflag_na=1
parameters ccoflag_na25=1
parameters rgflag_na25=1
parameters rcoflag_na25=1
parameters ccoflag_na25ud18=1
parameters rgflag_na25ud18=1
parameters rcoflag_na25ud18=1
parameters ccoflag_na25od33=1
parameters rgflag_na25od33=1
parameters rcoflag_na25od33=1
parameters ccoflag_cap=1
parameters ccoflag_cap_25=1
parameters ccoflag_hv25_snw_spw=1
parameters rgflag_hv25_snw_spw=1
endsection pre_simu

section ttmacro_mos_moscap
setscale options scalefactor=0.9
include "./crn40lp_2d5_v1d3.scs" section=global_rfmos
include "./crn40lp_2d5_v1d3.scs" section=tt_rfmos
include "./crn40lp_2d5_v1d3.scs" section=total_rf_mos
include "./crn40lp_2d5_v1d3.scs" section=global_rfmos_hvt
include "./crn40lp_2d5_v1d3.scs" section=tt_rfmos_hvt
include "./crn40lp_2d5_v1d3.scs" section=total_rf_mos_hvt
include "./crn40lp_2d5_v1d3.scs" section=global_rfmos_lvt
include "./crn40lp_2d5_v1d3.scs" section=tt_rfmos_lvt
include "./crn40lp_2d5_v1d3.scs" section=total_rf_mos_lvt
include "./crn40lp_2d5_v1d3.scs" section=global_rfmos_25ud18
include "./crn40lp_2d5_v1d3.scs" section=tt_rfmos_25ud18
include "./crn40lp_2d5_v1d3.scs" section=total_rf_mos_25ud18
include "./crn40lp_2d5_v1d3.scs" section=global_rfmos_25
include "./crn40lp_2d5_v1d3.scs" section=tt_rfmos_25
include "./crn40lp_2d5_v1d3.scs" section=total_rf_mos_25
include "./crn40lp_2d5_v1d3.scs" section=global_rfmos_25od33
include "./crn40lp_2d5_v1d3.scs" section=tt_rfmos_25od33
include "./crn40lp_2d5_v1d3.scs" section=total_rf_mos_25od33
include "./crn40lp_2d5_v1d3.scs" section=tt_rfmvar
include "./crn40lp_2d5_v1d3.scs" section=tt_rfmvar_25
include "./crn40lp_2d5_v1d3.scs" section=stat
include "./crn40lp_2d5_v1d3.scs" section=global
include "./crn40lp_2d5_v1d3.scs" section=tt
include "./crn40lp_2d5_v1d3.scs" section=global_hvt
include "./crn40lp_2d5_v1d3.scs" section=tt_hvt
include "./crn40lp_2d5_v1d3.scs" section=global_lvt
include "./crn40lp_2d5_v1d3.scs" section=tt_lvt
include "./crn40lp_2d5_v1d3.scs" section=global_25
include "./crn40lp_2d5_v1d3.scs" section=tt_25
include "./crn40lp_2d5_v1d3.scs" section=global_25ud18
include "./crn40lp_2d5_v1d3.scs" section=tt_25ud18
include "./crn40lp_2d5_v1d3.scs" section=global_25od33
include "./crn40lp_2d5_v1d3.scs" section=tt_25od33
include "./crn40lp_2d5_v1d3.scs" section=global_na
include "./crn40lp_2d5_v1d3.scs" section=tt_na
include "./crn40lp_2d5_v1d3.scs" section=global_na25
include "./crn40lp_2d5_v1d3.scs" section=tt_na25
include "./crn40lp_2d5_v1d3.scs" section=global_na25ud18
include "./crn40lp_2d5_v1d3.scs" section=tt_na25ud18
include "./crn40lp_2d5_v1d3.scs" section=global_na25od33
include "./crn40lp_2d5_v1d3.scs" section=tt_na25od33
include "./crn40lp_2d5_v1d3.scs" section=total
include "./crn40lp_2d5_v1d3.scs" section=total_hvt
include "./crn40lp_2d5_v1d3.scs" section=total_lvt
include "./crn40lp_2d5_v1d3.scs" section=total_25
include "./crn40lp_2d5_v1d3.scs" section=total_25ud18
include "./crn40lp_2d5_v1d3.scs" section=total_25od33
include "./crn40lp_2d5_v1d3.scs" section=total_na
include "./crn40lp_2d5_v1d3.scs" section=total_na25
include "./crn40lp_2d5_v1d3.scs" section=total_na25ud18
include "./crn40lp_2d5_v1d3.scs" section=total_na25od33
include "./crn40lp_2d5_v1d3.scs" section=tt_mos_cap
include "./crn40lp_2d5_v1d3.scs" section=tt_mos_cap_25
endsection ttmacro_mos_moscap

section ssmacro_mos_moscap
setscale options scalefactor=0.9
include "./crn40lp_2d5_v1d3.scs" section=global_rfmos
include "./crn40lp_2d5_v1d3.scs" section=ss_rfmos
include "./crn40lp_2d5_v1d3.scs" section=total_rf_mos
include "./crn40lp_2d5_v1d3.scs" section=global_rfmos_hvt
include "./crn40lp_2d5_v1d3.scs" section=ss_rfmos_hvt
include "./crn40lp_2d5_v1d3.scs" section=total_rf_mos_hvt
include "./crn40lp_2d5_v1d3.scs" section=global_rfmos_lvt
include "./crn40lp_2d5_v1d3.scs" section=ss_rfmos_lvt
include "./crn40lp_2d5_v1d3.scs" section=total_rf_mos_lvt
include "./crn40lp_2d5_v1d3.scs" section=global_rfmos_25ud18
include "./crn40lp_2d5_v1d3.scs" section=ss_rfmos_25ud18
include "./crn40lp_2d5_v1d3.scs" section=total_rf_mos_25ud18
include "./crn40lp_2d5_v1d3.scs" section=global_rfmos_25
include "./crn40lp_2d5_v1d3.scs" section=ss_rfmos_25
include "./crn40lp_2d5_v1d3.scs" section=total_rf_mos_25
include "./crn40lp_2d5_v1d3.scs" section=global_rfmos_25od33
include "./crn40lp_2d5_v1d3.scs" section=ss_rfmos_25od33
include "./crn40lp_2d5_v1d3.scs" section=total_rf_mos_25od33
include "./crn40lp_2d5_v1d3.scs" section=ss_rfmvar
include "./crn40lp_2d5_v1d3.scs" section=ss_rfmvar_25
include "./crn40lp_2d5_v1d3.scs" section=stat
include "./crn40lp_2d5_v1d3.scs" section=global
include "./crn40lp_2d5_v1d3.scs" section=ss
include "./crn40lp_2d5_v1d3.scs" section=global_hvt
include "./crn40lp_2d5_v1d3.scs" section=ss_hvt
include "./crn40lp_2d5_v1d3.scs" section=global_lvt
include "./crn40lp_2d5_v1d3.scs" section=ss_lvt
include "./crn40lp_2d5_v1d3.scs" section=global_25
include "./crn40lp_2d5_v1d3.scs" section=ss_25
include "./crn40lp_2d5_v1d3.scs" section=global_25ud18
include "./crn40lp_2d5_v1d3.scs" section=ss_25ud18
include "./crn40lp_2d5_v1d3.scs" section=global_25od33
include "./crn40lp_2d5_v1d3.scs" section=ss_25od33
include "./crn40lp_2d5_v1d3.scs" section=global_na
include "./crn40lp_2d5_v1d3.scs" section=ss_na
include "./crn40lp_2d5_v1d3.scs" section=global_na25
include "./crn40lp_2d5_v1d3.scs" section=ss_na25
include "./crn40lp_2d5_v1d3.scs" section=global_na25ud18
include "./crn40lp_2d5_v1d3.scs" section=ss_na25ud18
include "./crn40lp_2d5_v1d3.scs" section=global_na25od33
include "./crn40lp_2d5_v1d3.scs" section=ss_na25od33
include "./crn40lp_2d5_v1d3.scs" section=total
include "./crn40lp_2d5_v1d3.scs" section=total_hvt
include "./crn40lp_2d5_v1d3.scs" section=total_lvt
include "./crn40lp_2d5_v1d3.scs" section=total_25
include "./crn40lp_2d5_v1d3.scs" section=total_25ud18
include "./crn40lp_2d5_v1d3.scs" section=total_25od33
include "./crn40lp_2d5_v1d3.scs" section=total_na
include "./crn40lp_2d5_v1d3.scs" section=total_na25
include "./crn40lp_2d5_v1d3.scs" section=total_na25ud18
include "./crn40lp_2d5_v1d3.scs" section=total_na25od33
include "./crn40lp_2d5_v1d3.scs" section=ss_mos_cap
include "./crn40lp_2d5_v1d3.scs" section=ss_mos_cap_25
endsection ssmacro_mos_moscap

section ffmacro_mos_moscap
setscale options scalefactor=0.9
include "./crn40lp_2d5_v1d3.scs" section=global_rfmos
include "./crn40lp_2d5_v1d3.scs" section=ff_rfmos
include "./crn40lp_2d5_v1d3.scs" section=total_rf_mos
include "./crn40lp_2d5_v1d3.scs" section=global_rfmos_hvt
include "./crn40lp_2d5_v1d3.scs" section=ff_rfmos_hvt
include "./crn40lp_2d5_v1d3.scs" section=total_rf_mos_hvt
include "./crn40lp_2d5_v1d3.scs" section=global_rfmos_lvt
include "./crn40lp_2d5_v1d3.scs" section=ff_rfmos_lvt
include "./crn40lp_2d5_v1d3.scs" section=total_rf_mos_lvt
include "./crn40lp_2d5_v1d3.scs" section=global_rfmos_25ud18
include "./crn40lp_2d5_v1d3.scs" section=ff_rfmos_25ud18
include "./crn40lp_2d5_v1d3.scs" section=total_rf_mos_25ud18
include "./crn40lp_2d5_v1d3.scs" section=global_rfmos_25
include "./crn40lp_2d5_v1d3.scs" section=ff_rfmos_25
include "./crn40lp_2d5_v1d3.scs" section=total_rf_mos_25
include "./crn40lp_2d5_v1d3.scs" section=global_rfmos_25od33
include "./crn40lp_2d5_v1d3.scs" section=ff_rfmos_25od33
include "./crn40lp_2d5_v1d3.scs" section=total_rf_mos_25od33
include "./crn40lp_2d5_v1d3.scs" section=ff_rfmvar
include "./crn40lp_2d5_v1d3.scs" section=ff_rfmvar_25
include "./crn40lp_2d5_v1d3.scs" section=stat
include "./crn40lp_2d5_v1d3.scs" section=global
include "./crn40lp_2d5_v1d3.scs" section=ff
include "./crn40lp_2d5_v1d3.scs" section=global_hvt
include "./crn40lp_2d5_v1d3.scs" section=ff_hvt
include "./crn40lp_2d5_v1d3.scs" section=global_lvt
include "./crn40lp_2d5_v1d3.scs" section=ff_lvt
include "./crn40lp_2d5_v1d3.scs" section=global_25
include "./crn40lp_2d5_v1d3.scs" section=ff_25
include "./crn40lp_2d5_v1d3.scs" section=global_25ud18
include "./crn40lp_2d5_v1d3.scs" section=ff_25ud18
include "./crn40lp_2d5_v1d3.scs" section=global_25od33
include "./crn40lp_2d5_v1d3.scs" section=ff_25od33
include "./crn40lp_2d5_v1d3.scs" section=global_na
include "./crn40lp_2d5_v1d3.scs" section=ff_na
include "./crn40lp_2d5_v1d3.scs" section=global_na25
include "./crn40lp_2d5_v1d3.scs" section=ff_na25
include "./crn40lp_2d5_v1d3.scs" section=global_na25ud18
include "./crn40lp_2d5_v1d3.scs" section=ff_na25ud18
include "./crn40lp_2d5_v1d3.scs" section=global_na25od33
include "./crn40lp_2d5_v1d3.scs" section=ff_na25od33
include "./crn40lp_2d5_v1d3.scs" section=total
include "./crn40lp_2d5_v1d3.scs" section=total_hvt
include "./crn40lp_2d5_v1d3.scs" section=total_lvt
include "./crn40lp_2d5_v1d3.scs" section=total_25
include "./crn40lp_2d5_v1d3.scs" section=total_25ud18
include "./crn40lp_2d5_v1d3.scs" section=total_25od33
include "./crn40lp_2d5_v1d3.scs" section=total_na
include "./crn40lp_2d5_v1d3.scs" section=total_na25
include "./crn40lp_2d5_v1d3.scs" section=total_na25ud18
include "./crn40lp_2d5_v1d3.scs" section=total_na25od33
include "./crn40lp_2d5_v1d3.scs" section=ff_mos_cap
include "./crn40lp_2d5_v1d3.scs" section=ff_mos_cap_25
endsection ffmacro_mos_moscap

section sfmacro_mos_moscap
setscale options scalefactor=0.9
include "./crn40lp_2d5_v1d3.scs" section=global_rfmos
include "./crn40lp_2d5_v1d3.scs" section=sf_rfmos
include "./crn40lp_2d5_v1d3.scs" section=total_rf_mos
include "./crn40lp_2d5_v1d3.scs" section=global_rfmos_hvt
include "./crn40lp_2d5_v1d3.scs" section=sf_rfmos_hvt
include "./crn40lp_2d5_v1d3.scs" section=total_rf_mos_hvt
include "./crn40lp_2d5_v1d3.scs" section=global_rfmos_lvt
include "./crn40lp_2d5_v1d3.scs" section=sf_rfmos_lvt
include "./crn40lp_2d5_v1d3.scs" section=total_rf_mos_lvt
include "./crn40lp_2d5_v1d3.scs" section=global_rfmos_25ud18
include "./crn40lp_2d5_v1d3.scs" section=sf_rfmos_25ud18
include "./crn40lp_2d5_v1d3.scs" section=total_rf_mos_25ud18
include "./crn40lp_2d5_v1d3.scs" section=global_rfmos_25
include "./crn40lp_2d5_v1d3.scs" section=sf_rfmos_25
include "./crn40lp_2d5_v1d3.scs" section=total_rf_mos_25
include "./crn40lp_2d5_v1d3.scs" section=global_rfmos_25od33
include "./crn40lp_2d5_v1d3.scs" section=sf_rfmos_25od33
include "./crn40lp_2d5_v1d3.scs" section=total_rf_mos_25od33
include "./crn40lp_2d5_v1d3.scs" section=tt_rfmvar
include "./crn40lp_2d5_v1d3.scs" section=tt_rfmvar_25
include "./crn40lp_2d5_v1d3.scs" section=stat
include "./crn40lp_2d5_v1d3.scs" section=global
include "./crn40lp_2d5_v1d3.scs" section=sf
include "./crn40lp_2d5_v1d3.scs" section=global_hvt
include "./crn40lp_2d5_v1d3.scs" section=sf_hvt
include "./crn40lp_2d5_v1d3.scs" section=global_lvt
include "./crn40lp_2d5_v1d3.scs" section=sf_lvt
include "./crn40lp_2d5_v1d3.scs" section=global_25
include "./crn40lp_2d5_v1d3.scs" section=sf_25
include "./crn40lp_2d5_v1d3.scs" section=global_25ud18
include "./crn40lp_2d5_v1d3.scs" section=sf_25ud18
include "./crn40lp_2d5_v1d3.scs" section=global_25od33
include "./crn40lp_2d5_v1d3.scs" section=sf_25od33
include "./crn40lp_2d5_v1d3.scs" section=global_na
include "./crn40lp_2d5_v1d3.scs" section=sf_na
include "./crn40lp_2d5_v1d3.scs" section=global_na25
include "./crn40lp_2d5_v1d3.scs" section=sf_na25
include "./crn40lp_2d5_v1d3.scs" section=global_na25ud18
include "./crn40lp_2d5_v1d3.scs" section=sf_na25ud18
include "./crn40lp_2d5_v1d3.scs" section=global_na25od33
include "./crn40lp_2d5_v1d3.scs" section=sf_na25od33
include "./crn40lp_2d5_v1d3.scs" section=total
include "./crn40lp_2d5_v1d3.scs" section=total_hvt
include "./crn40lp_2d5_v1d3.scs" section=total_lvt
include "./crn40lp_2d5_v1d3.scs" section=total_25
include "./crn40lp_2d5_v1d3.scs" section=total_25ud18
include "./crn40lp_2d5_v1d3.scs" section=total_25od33
include "./crn40lp_2d5_v1d3.scs" section=total_na
include "./crn40lp_2d5_v1d3.scs" section=total_na25
include "./crn40lp_2d5_v1d3.scs" section=total_na25ud18
include "./crn40lp_2d5_v1d3.scs" section=total_na25od33
include "./crn40lp_2d5_v1d3.scs" section=tt_mos_cap
include "./crn40lp_2d5_v1d3.scs" section=tt_mos_cap_25
endsection sfmacro_mos_moscap

section fsmacro_mos_moscap
setscale options scalefactor=0.9
include "./crn40lp_2d5_v1d3.scs" section=global_rfmos
include "./crn40lp_2d5_v1d3.scs" section=fs_rfmos
include "./crn40lp_2d5_v1d3.scs" section=total_rf_mos
include "./crn40lp_2d5_v1d3.scs" section=global_rfmos_hvt
include "./crn40lp_2d5_v1d3.scs" section=fs_rfmos_hvt
include "./crn40lp_2d5_v1d3.scs" section=total_rf_mos_hvt
include "./crn40lp_2d5_v1d3.scs" section=global_rfmos_lvt
include "./crn40lp_2d5_v1d3.scs" section=fs_rfmos_lvt
include "./crn40lp_2d5_v1d3.scs" section=total_rf_mos_lvt
include "./crn40lp_2d5_v1d3.scs" section=global_rfmos_25ud18
include "./crn40lp_2d5_v1d3.scs" section=fs_rfmos_25ud18
include "./crn40lp_2d5_v1d3.scs" section=total_rf_mos_25ud18
include "./crn40lp_2d5_v1d3.scs" section=global_rfmos_25
include "./crn40lp_2d5_v1d3.scs" section=fs_rfmos_25
include "./crn40lp_2d5_v1d3.scs" section=total_rf_mos_25
include "./crn40lp_2d5_v1d3.scs" section=global_rfmos_25od33
include "./crn40lp_2d5_v1d3.scs" section=fs_rfmos_25od33
include "./crn40lp_2d5_v1d3.scs" section=total_rf_mos_25od33
include "./crn40lp_2d5_v1d3.scs" section=tt_rfmvar
include "./crn40lp_2d5_v1d3.scs" section=tt_rfmvar_25
include "./crn40lp_2d5_v1d3.scs" section=stat
include "./crn40lp_2d5_v1d3.scs" section=global
include "./crn40lp_2d5_v1d3.scs" section=fs
include "./crn40lp_2d5_v1d3.scs" section=global_hvt
include "./crn40lp_2d5_v1d3.scs" section=fs_hvt
include "./crn40lp_2d5_v1d3.scs" section=global_lvt
include "./crn40lp_2d5_v1d3.scs" section=fs_lvt
include "./crn40lp_2d5_v1d3.scs" section=global_25
include "./crn40lp_2d5_v1d3.scs" section=fs_25
include "./crn40lp_2d5_v1d3.scs" section=global_25ud18
include "./crn40lp_2d5_v1d3.scs" section=fs_25ud18
include "./crn40lp_2d5_v1d3.scs" section=global_25od33
include "./crn40lp_2d5_v1d3.scs" section=fs_25od33
include "./crn40lp_2d5_v1d3.scs" section=global_na
include "./crn40lp_2d5_v1d3.scs" section=fs_na
include "./crn40lp_2d5_v1d3.scs" section=global_na25
include "./crn40lp_2d5_v1d3.scs" section=fs_na25
include "./crn40lp_2d5_v1d3.scs" section=global_na25ud18
include "./crn40lp_2d5_v1d3.scs" section=fs_na25ud18
include "./crn40lp_2d5_v1d3.scs" section=global_na25od33
include "./crn40lp_2d5_v1d3.scs" section=fs_na25od33
include "./crn40lp_2d5_v1d3.scs" section=total
include "./crn40lp_2d5_v1d3.scs" section=total_hvt
include "./crn40lp_2d5_v1d3.scs" section=total_lvt
include "./crn40lp_2d5_v1d3.scs" section=total_25
include "./crn40lp_2d5_v1d3.scs" section=total_25ud18
include "./crn40lp_2d5_v1d3.scs" section=total_25od33
include "./crn40lp_2d5_v1d3.scs" section=total_na
include "./crn40lp_2d5_v1d3.scs" section=total_na25
include "./crn40lp_2d5_v1d3.scs" section=total_na25ud18
include "./crn40lp_2d5_v1d3.scs" section=total_na25od33
include "./crn40lp_2d5_v1d3.scs" section=tt_mos_cap
include "./crn40lp_2d5_v1d3.scs" section=tt_mos_cap_25
endsection fsmacro_mos_moscap

section ttglobalcorner_localmc_mos_moscap
setscale options scalefactor=0.9
include "./crn40lp_2d5_v1d3.scs" section=ttg_rfmos
include "./crn40lp_2d5_v1d3.scs" section=tt_rfmos
include "./crn40lp_2d5_v1d3.scs" section=total_rf_mos
include "./crn40lp_2d5_v1d3.scs" section=ttg_rfmos_hvt
include "./crn40lp_2d5_v1d3.scs" section=tt_rfmos_hvt
include "./crn40lp_2d5_v1d3.scs" section=total_rf_mos_hvt
include "./crn40lp_2d5_v1d3.scs" section=ttg_rfmos_lvt
include "./crn40lp_2d5_v1d3.scs" section=tt_rfmos_lvt
include "./crn40lp_2d5_v1d3.scs" section=total_rf_mos_lvt
include "./crn40lp_2d5_v1d3.scs" section=ttg_rfmos_25ud18
include "./crn40lp_2d5_v1d3.scs" section=tt_rfmos_25ud18
include "./crn40lp_2d5_v1d3.scs" section=total_rf_mos_25ud18
include "./crn40lp_2d5_v1d3.scs" section=ttg_rfmos_25
include "./crn40lp_2d5_v1d3.scs" section=tt_rfmos_25
include "./crn40lp_2d5_v1d3.scs" section=total_rf_mos_25
include "./crn40lp_2d5_v1d3.scs" section=ttg_rfmos_25od33
include "./crn40lp_2d5_v1d3.scs" section=tt_rfmos_25od33
include "./crn40lp_2d5_v1d3.scs" section=total_rf_mos_25od33
include "./crn40lp_2d5_v1d3.scs" section=tt_rfmvar
include "./crn40lp_2d5_v1d3.scs" section=tt_rfmvar_25
include "./crn40lp_2d5_v1d3.scs" section=stat
include "./crn40lp_2d5_v1d3.scs" section=ttg
include "./crn40lp_2d5_v1d3.scs" section=tt
include "./crn40lp_2d5_v1d3.scs" section=ttg_hvt
include "./crn40lp_2d5_v1d3.scs" section=tt_hvt
include "./crn40lp_2d5_v1d3.scs" section=ttg_lvt
include "./crn40lp_2d5_v1d3.scs" section=tt_lvt
include "./crn40lp_2d5_v1d3.scs" section=ttg_25
include "./crn40lp_2d5_v1d3.scs" section=tt_25
include "./crn40lp_2d5_v1d3.scs" section=ttg_25ud18
include "./crn40lp_2d5_v1d3.scs" section=tt_25ud18
include "./crn40lp_2d5_v1d3.scs" section=ttg_25od33
include "./crn40lp_2d5_v1d3.scs" section=tt_25od33
include "./crn40lp_2d5_v1d3.scs" section=ttg_na
include "./crn40lp_2d5_v1d3.scs" section=tt_na
include "./crn40lp_2d5_v1d3.scs" section=ttg_na25
include "./crn40lp_2d5_v1d3.scs" section=tt_na25
include "./crn40lp_2d5_v1d3.scs" section=ttg_na25ud18
include "./crn40lp_2d5_v1d3.scs" section=tt_na25ud18
include "./crn40lp_2d5_v1d3.scs" section=ttg_na25od33
include "./crn40lp_2d5_v1d3.scs" section=tt_na25od33
include "./crn40lp_2d5_v1d3.scs" section=total
include "./crn40lp_2d5_v1d3.scs" section=total_hvt
include "./crn40lp_2d5_v1d3.scs" section=total_lvt
include "./crn40lp_2d5_v1d3.scs" section=total_25
include "./crn40lp_2d5_v1d3.scs" section=total_25ud18
include "./crn40lp_2d5_v1d3.scs" section=total_25od33
include "./crn40lp_2d5_v1d3.scs" section=total_na
include "./crn40lp_2d5_v1d3.scs" section=total_na25
include "./crn40lp_2d5_v1d3.scs" section=total_na25ud18
include "./crn40lp_2d5_v1d3.scs" section=total_na25od33
include "./crn40lp_2d5_v1d3.scs" section=tt_mos_cap
include "./crn40lp_2d5_v1d3.scs" section=tt_mos_cap_25
parOpt options redefinedparams=ignore
parameters totalflag_mos_rf=0
parameters totalflag_mos_rf_hvt=0
parameters totalflag_mos_rf_lvt=0
parameters totalflag_mos_rf_25ud18=0
parameters totalflag_mos_rf_25=0
parameters totalflag_mos_rf_25od33=0
parameters totalflag_mos=0
parameters totalflag_mos_hvt=0
parameters totalflag_mos_lvt=0
parameters totalflag_mos_25=0
parameters totalflag_mos_25ud18=0
parameters totalflag_mos_25od33=0
parameters totalflag_mos_na=0
parameters totalflag_mos_na25=0
parameters totalflag_mos_na25ud18=0
parameters totalflag_mos_na25od33=0
endsection ttglobalcorner_localmc_mos_moscap

section ssglobalcorner_localmc_mos_moscap
setscale options scalefactor=0.9
include "./crn40lp_2d5_v1d3.scs" section=ssg_rfmos
include "./crn40lp_2d5_v1d3.scs" section=tt_rfmos
include "./crn40lp_2d5_v1d3.scs" section=total_rf_mos
include "./crn40lp_2d5_v1d3.scs" section=ssg_rfmos_hvt
include "./crn40lp_2d5_v1d3.scs" section=tt_rfmos_hvt
include "./crn40lp_2d5_v1d3.scs" section=total_rf_mos_hvt
include "./crn40lp_2d5_v1d3.scs" section=ssg_rfmos_lvt
include "./crn40lp_2d5_v1d3.scs" section=tt_rfmos_lvt
include "./crn40lp_2d5_v1d3.scs" section=total_rf_mos_lvt
include "./crn40lp_2d5_v1d3.scs" section=ssg_rfmos_25ud18
include "./crn40lp_2d5_v1d3.scs" section=tt_rfmos_25ud18
include "./crn40lp_2d5_v1d3.scs" section=total_rf_mos_25ud18
include "./crn40lp_2d5_v1d3.scs" section=ssg_rfmos_25
include "./crn40lp_2d5_v1d3.scs" section=tt_rfmos_25
include "./crn40lp_2d5_v1d3.scs" section=total_rf_mos_25
include "./crn40lp_2d5_v1d3.scs" section=ssg_rfmos_25od33
include "./crn40lp_2d5_v1d3.scs" section=tt_rfmos_25od33
include "./crn40lp_2d5_v1d3.scs" section=total_rf_mos_25od33
include "./crn40lp_2d5_v1d3.scs" section=ss_rfmvar
include "./crn40lp_2d5_v1d3.scs" section=ss_rfmvar_25
include "./crn40lp_2d5_v1d3.scs" section=stat
include "./crn40lp_2d5_v1d3.scs" section=ssg
include "./crn40lp_2d5_v1d3.scs" section=tt
include "./crn40lp_2d5_v1d3.scs" section=ssg_hvt
include "./crn40lp_2d5_v1d3.scs" section=tt_hvt
include "./crn40lp_2d5_v1d3.scs" section=ssg_lvt
include "./crn40lp_2d5_v1d3.scs" section=tt_lvt
include "./crn40lp_2d5_v1d3.scs" section=ssg_25
include "./crn40lp_2d5_v1d3.scs" section=tt_25
include "./crn40lp_2d5_v1d3.scs" section=ssg_25ud18
include "./crn40lp_2d5_v1d3.scs" section=tt_25ud18
include "./crn40lp_2d5_v1d3.scs" section=ssg_25od33
include "./crn40lp_2d5_v1d3.scs" section=tt_25od33
include "./crn40lp_2d5_v1d3.scs" section=ssg_na
include "./crn40lp_2d5_v1d3.scs" section=tt_na
include "./crn40lp_2d5_v1d3.scs" section=ssg_na25
include "./crn40lp_2d5_v1d3.scs" section=tt_na25
include "./crn40lp_2d5_v1d3.scs" section=ssg_na25ud18
include "./crn40lp_2d5_v1d3.scs" section=tt_na25ud18
include "./crn40lp_2d5_v1d3.scs" section=ssg_na25od33
include "./crn40lp_2d5_v1d3.scs" section=tt_na25od33
include "./crn40lp_2d5_v1d3.scs" section=total
include "./crn40lp_2d5_v1d3.scs" section=total_hvt
include "./crn40lp_2d5_v1d3.scs" section=total_lvt
include "./crn40lp_2d5_v1d3.scs" section=total_25
include "./crn40lp_2d5_v1d3.scs" section=total_25ud18
include "./crn40lp_2d5_v1d3.scs" section=total_25od33
include "./crn40lp_2d5_v1d3.scs" section=total_na
include "./crn40lp_2d5_v1d3.scs" section=total_na25
include "./crn40lp_2d5_v1d3.scs" section=total_na25ud18
include "./crn40lp_2d5_v1d3.scs" section=total_na25od33
include "./crn40lp_2d5_v1d3.scs" section=ss_mos_cap
include "./crn40lp_2d5_v1d3.scs" section=ss_mos_cap_25
parOpt options redefinedparams=ignore
parameters totalflag_mos_rf=0
parameters totalflag_mos_rf_hvt=0
parameters totalflag_mos_rf_lvt=0
parameters totalflag_mos_rf_25ud18=0
parameters totalflag_mos_rf_25=0
parameters totalflag_mos_rf_25od33=0
parameters totalflag_mos=0
parameters totalflag_mos_hvt=0
parameters totalflag_mos_lvt=0
parameters totalflag_mos_25=0
parameters totalflag_mos_25ud18=0
parameters totalflag_mos_25od33=0
parameters totalflag_mos_na=0
parameters totalflag_mos_na25=0
parameters totalflag_mos_na25ud18=0
parameters totalflag_mos_na25od33=0
endsection ssglobalcorner_localmc_mos_moscap

section ffglobalcorner_localmc_mos_moscap
setscale options scalefactor=0.9
include "./crn40lp_2d5_v1d3.scs" section=ffg_rfmos
include "./crn40lp_2d5_v1d3.scs" section=tt_rfmos
include "./crn40lp_2d5_v1d3.scs" section=total_rf_mos
include "./crn40lp_2d5_v1d3.scs" section=ffg_rfmos_hvt
include "./crn40lp_2d5_v1d3.scs" section=tt_rfmos_hvt
include "./crn40lp_2d5_v1d3.scs" section=total_rf_mos_hvt
include "./crn40lp_2d5_v1d3.scs" section=ffg_rfmos_lvt
include "./crn40lp_2d5_v1d3.scs" section=tt_rfmos_lvt
include "./crn40lp_2d5_v1d3.scs" section=total_rf_mos_lvt
include "./crn40lp_2d5_v1d3.scs" section=ffg_rfmos_25ud18
include "./crn40lp_2d5_v1d3.scs" section=tt_rfmos_25ud18
include "./crn40lp_2d5_v1d3.scs" section=total_rf_mos_25ud18
include "./crn40lp_2d5_v1d3.scs" section=ffg_rfmos_25
include "./crn40lp_2d5_v1d3.scs" section=tt_rfmos_25
include "./crn40lp_2d5_v1d3.scs" section=total_rf_mos_25
include "./crn40lp_2d5_v1d3.scs" section=ffg_rfmos_25od33
include "./crn40lp_2d5_v1d3.scs" section=tt_rfmos_25od33
include "./crn40lp_2d5_v1d3.scs" section=total_rf_mos_25od33
include "./crn40lp_2d5_v1d3.scs" section=ff_rfmvar
include "./crn40lp_2d5_v1d3.scs" section=ff_rfmvar_25
include "./crn40lp_2d5_v1d3.scs" section=stat
include "./crn40lp_2d5_v1d3.scs" section=ffg
include "./crn40lp_2d5_v1d3.scs" section=tt
include "./crn40lp_2d5_v1d3.scs" section=ffg_hvt
include "./crn40lp_2d5_v1d3.scs" section=tt_hvt
include "./crn40lp_2d5_v1d3.scs" section=ffg_lvt
include "./crn40lp_2d5_v1d3.scs" section=tt_lvt
include "./crn40lp_2d5_v1d3.scs" section=ffg_25
include "./crn40lp_2d5_v1d3.scs" section=tt_25
include "./crn40lp_2d5_v1d3.scs" section=ffg_25ud18
include "./crn40lp_2d5_v1d3.scs" section=tt_25ud18
include "./crn40lp_2d5_v1d3.scs" section=ffg_25od33
include "./crn40lp_2d5_v1d3.scs" section=tt_25od33
include "./crn40lp_2d5_v1d3.scs" section=ffg_na
include "./crn40lp_2d5_v1d3.scs" section=tt_na
include "./crn40lp_2d5_v1d3.scs" section=ffg_na25
include "./crn40lp_2d5_v1d3.scs" section=tt_na25
include "./crn40lp_2d5_v1d3.scs" section=ffg_na25ud18
include "./crn40lp_2d5_v1d3.scs" section=tt_na25ud18
include "./crn40lp_2d5_v1d3.scs" section=ffg_na25od33
include "./crn40lp_2d5_v1d3.scs" section=tt_na25od33
include "./crn40lp_2d5_v1d3.scs" section=total
include "./crn40lp_2d5_v1d3.scs" section=total_hvt
include "./crn40lp_2d5_v1d3.scs" section=total_lvt
include "./crn40lp_2d5_v1d3.scs" section=total_25
include "./crn40lp_2d5_v1d3.scs" section=total_25ud18
include "./crn40lp_2d5_v1d3.scs" section=total_25od33
include "./crn40lp_2d5_v1d3.scs" section=total_na
include "./crn40lp_2d5_v1d3.scs" section=total_na25
include "./crn40lp_2d5_v1d3.scs" section=total_na25ud18
include "./crn40lp_2d5_v1d3.scs" section=total_na25od33
include "./crn40lp_2d5_v1d3.scs" section=ff_mos_cap
include "./crn40lp_2d5_v1d3.scs" section=ff_mos_cap_25
parOpt options redefinedparams=ignore
parameters totalflag_mos_rf=0
parameters totalflag_mos_rf_hvt=0
parameters totalflag_mos_rf_lvt=0
parameters totalflag_mos_rf_25ud18=0
parameters totalflag_mos_rf_25=0
parameters totalflag_mos_rf_25od33=0
parameters totalflag_mos=0
parameters totalflag_mos_hvt=0
parameters totalflag_mos_lvt=0
parameters totalflag_mos_25=0
parameters totalflag_mos_25ud18=0
parameters totalflag_mos_25od33=0
parameters totalflag_mos_na=0
parameters totalflag_mos_na25=0
parameters totalflag_mos_na25ud18=0
parameters totalflag_mos_na25od33=0
endsection ffglobalcorner_localmc_mos_moscap

section sfglobalcorner_localmc_mos_moscap
setscale options scalefactor=0.9
include "./crn40lp_2d5_v1d3.scs" section=sfg_rfmos
include "./crn40lp_2d5_v1d3.scs" section=tt_rfmos
include "./crn40lp_2d5_v1d3.scs" section=total_rf_mos
include "./crn40lp_2d5_v1d3.scs" section=sfg_rfmos_hvt
include "./crn40lp_2d5_v1d3.scs" section=tt_rfmos_hvt
include "./crn40lp_2d5_v1d3.scs" section=total_rf_mos_hvt
include "./crn40lp_2d5_v1d3.scs" section=sfg_rfmos_lvt
include "./crn40lp_2d5_v1d3.scs" section=tt_rfmos_lvt
include "./crn40lp_2d5_v1d3.scs" section=total_rf_mos_lvt
include "./crn40lp_2d5_v1d3.scs" section=sfg_rfmos_25ud18
include "./crn40lp_2d5_v1d3.scs" section=tt_rfmos_25ud18
include "./crn40lp_2d5_v1d3.scs" section=total_rf_mos_25ud18
include "./crn40lp_2d5_v1d3.scs" section=sfg_rfmos_25
include "./crn40lp_2d5_v1d3.scs" section=tt_rfmos_25
include "./crn40lp_2d5_v1d3.scs" section=total_rf_mos_25
include "./crn40lp_2d5_v1d3.scs" section=sfg_rfmos_25od33
include "./crn40lp_2d5_v1d3.scs" section=tt_rfmos_25od33
include "./crn40lp_2d5_v1d3.scs" section=total_rf_mos_25od33
include "./crn40lp_2d5_v1d3.scs" section=tt_rfmvar
include "./crn40lp_2d5_v1d3.scs" section=tt_rfmvar_25
include "./crn40lp_2d5_v1d3.scs" section=stat
include "./crn40lp_2d5_v1d3.scs" section=sfg
include "./crn40lp_2d5_v1d3.scs" section=tt
include "./crn40lp_2d5_v1d3.scs" section=sfg_hvt
include "./crn40lp_2d5_v1d3.scs" section=tt_hvt
include "./crn40lp_2d5_v1d3.scs" section=sfg_lvt
include "./crn40lp_2d5_v1d3.scs" section=tt_lvt
include "./crn40lp_2d5_v1d3.scs" section=sfg_25
include "./crn40lp_2d5_v1d3.scs" section=tt_25
include "./crn40lp_2d5_v1d3.scs" section=sfg_25ud18
include "./crn40lp_2d5_v1d3.scs" section=tt_25ud18
include "./crn40lp_2d5_v1d3.scs" section=sfg_25od33
include "./crn40lp_2d5_v1d3.scs" section=tt_25od33
include "./crn40lp_2d5_v1d3.scs" section=sfg_na
include "./crn40lp_2d5_v1d3.scs" section=tt_na
include "./crn40lp_2d5_v1d3.scs" section=sfg_na25
include "./crn40lp_2d5_v1d3.scs" section=tt_na25
include "./crn40lp_2d5_v1d3.scs" section=sfg_na25ud18
include "./crn40lp_2d5_v1d3.scs" section=tt_na25ud18
include "./crn40lp_2d5_v1d3.scs" section=sfg_na25od33
include "./crn40lp_2d5_v1d3.scs" section=tt_na25od33
include "./crn40lp_2d5_v1d3.scs" section=total
include "./crn40lp_2d5_v1d3.scs" section=total_hvt
include "./crn40lp_2d5_v1d3.scs" section=total_lvt
include "./crn40lp_2d5_v1d3.scs" section=total_25
include "./crn40lp_2d5_v1d3.scs" section=total_25ud18
include "./crn40lp_2d5_v1d3.scs" section=total_25od33
include "./crn40lp_2d5_v1d3.scs" section=total_na
include "./crn40lp_2d5_v1d3.scs" section=total_na25
include "./crn40lp_2d5_v1d3.scs" section=total_na25ud18
include "./crn40lp_2d5_v1d3.scs" section=total_na25od33
include "./crn40lp_2d5_v1d3.scs" section=tt_mos_cap
include "./crn40lp_2d5_v1d3.scs" section=tt_mos_cap_25
parOpt options redefinedparams=ignore
parameters totalflag_mos_rf=0
parameters totalflag_mos_rf_hvt=0
parameters totalflag_mos_rf_lvt=0
parameters totalflag_mos_rf_25ud18=0
parameters totalflag_mos_rf_25=0
parameters totalflag_mos_rf_25od33=0
parameters totalflag_mos=0
parameters totalflag_mos_hvt=0
parameters totalflag_mos_lvt=0
parameters totalflag_mos_25=0
parameters totalflag_mos_25ud18=0
parameters totalflag_mos_25od33=0
parameters totalflag_mos_na=0
parameters totalflag_mos_na25=0
parameters totalflag_mos_na25ud18=0
parameters totalflag_mos_na25od33=0
endsection sfglobalcorner_localmc_mos_moscap

section fsglobalcorner_localmc_mos_moscap
setscale options scalefactor=0.9
include "./crn40lp_2d5_v1d3.scs" section=fsg_rfmos
include "./crn40lp_2d5_v1d3.scs" section=tt_rfmos
include "./crn40lp_2d5_v1d3.scs" section=total_rf_mos
include "./crn40lp_2d5_v1d3.scs" section=fsg_rfmos_hvt
include "./crn40lp_2d5_v1d3.scs" section=tt_rfmos_hvt
include "./crn40lp_2d5_v1d3.scs" section=total_rf_mos_hvt
include "./crn40lp_2d5_v1d3.scs" section=fsg_rfmos_lvt
include "./crn40lp_2d5_v1d3.scs" section=tt_rfmos_lvt
include "./crn40lp_2d5_v1d3.scs" section=total_rf_mos_lvt
include "./crn40lp_2d5_v1d3.scs" section=fsg_rfmos_25ud18
include "./crn40lp_2d5_v1d3.scs" section=tt_rfmos_25ud18
include "./crn40lp_2d5_v1d3.scs" section=total_rf_mos_25ud18
include "./crn40lp_2d5_v1d3.scs" section=fsg_rfmos_25
include "./crn40lp_2d5_v1d3.scs" section=tt_rfmos_25
include "./crn40lp_2d5_v1d3.scs" section=total_rf_mos_25
include "./crn40lp_2d5_v1d3.scs" section=fsg_rfmos_25od33
include "./crn40lp_2d5_v1d3.scs" section=tt_rfmos_25od33
include "./crn40lp_2d5_v1d3.scs" section=total_rf_mos_25od33
include "./crn40lp_2d5_v1d3.scs" section=tt_rfmvar
include "./crn40lp_2d5_v1d3.scs" section=tt_rfmvar_25
include "./crn40lp_2d5_v1d3.scs" section=stat
include "./crn40lp_2d5_v1d3.scs" section=fsg
include "./crn40lp_2d5_v1d3.scs" section=tt
include "./crn40lp_2d5_v1d3.scs" section=fsg_hvt
include "./crn40lp_2d5_v1d3.scs" section=tt_hvt
include "./crn40lp_2d5_v1d3.scs" section=fsg_lvt
include "./crn40lp_2d5_v1d3.scs" section=tt_lvt
include "./crn40lp_2d5_v1d3.scs" section=fsg_25
include "./crn40lp_2d5_v1d3.scs" section=tt_25
include "./crn40lp_2d5_v1d3.scs" section=fsg_25ud18
include "./crn40lp_2d5_v1d3.scs" section=tt_25ud18
include "./crn40lp_2d5_v1d3.scs" section=fsg_25od33
include "./crn40lp_2d5_v1d3.scs" section=tt_25od33
include "./crn40lp_2d5_v1d3.scs" section=fsg_na
include "./crn40lp_2d5_v1d3.scs" section=tt_na
include "./crn40lp_2d5_v1d3.scs" section=fsg_na25
include "./crn40lp_2d5_v1d3.scs" section=tt_na25
include "./crn40lp_2d5_v1d3.scs" section=fsg_na25ud18
include "./crn40lp_2d5_v1d3.scs" section=tt_na25ud18
include "./crn40lp_2d5_v1d3.scs" section=fsg_na25od33
include "./crn40lp_2d5_v1d3.scs" section=tt_na25od33
include "./crn40lp_2d5_v1d3.scs" section=total
include "./crn40lp_2d5_v1d3.scs" section=total_hvt
include "./crn40lp_2d5_v1d3.scs" section=total_lvt
include "./crn40lp_2d5_v1d3.scs" section=total_25
include "./crn40lp_2d5_v1d3.scs" section=total_25ud18
include "./crn40lp_2d5_v1d3.scs" section=total_25od33
include "./crn40lp_2d5_v1d3.scs" section=total_na
include "./crn40lp_2d5_v1d3.scs" section=total_na25
include "./crn40lp_2d5_v1d3.scs" section=total_na25ud18
include "./crn40lp_2d5_v1d3.scs" section=total_na25od33
include "./crn40lp_2d5_v1d3.scs" section=tt_mos_cap
include "./crn40lp_2d5_v1d3.scs" section=tt_mos_cap_25
parOpt options redefinedparams=ignore
parameters totalflag_mos_rf=0
parameters totalflag_mos_rf_hvt=0
parameters totalflag_mos_rf_lvt=0
parameters totalflag_mos_rf_25ud18=0
parameters totalflag_mos_rf_25=0
parameters totalflag_mos_rf_25od33=0
parameters totalflag_mos=0
parameters totalflag_mos_hvt=0
parameters totalflag_mos_lvt=0
parameters totalflag_mos_25=0
parameters totalflag_mos_25ud18=0
parameters totalflag_mos_25od33=0
parameters totalflag_mos_na=0
parameters totalflag_mos_na25=0
parameters totalflag_mos_na25ud18=0
parameters totalflag_mos_na25od33=0
endsection fsglobalcorner_localmc_mos_moscap

section localmconly_mos_moscap
setscale options scalefactor=0.9
include "./crn40lp_2d5_v1d3.scs" section=global_rfmos
include "./crn40lp_2d5_v1d3.scs" section=tt_rfmos
include "./crn40lp_2d5_v1d3.scs" section=total_rf_mos
include "./crn40lp_2d5_v1d3.scs" section=global_rfmos_hvt
include "./crn40lp_2d5_v1d3.scs" section=tt_rfmos_hvt
include "./crn40lp_2d5_v1d3.scs" section=total_rf_mos_hvt
include "./crn40lp_2d5_v1d3.scs" section=global_rfmos_lvt
include "./crn40lp_2d5_v1d3.scs" section=tt_rfmos_lvt
include "./crn40lp_2d5_v1d3.scs" section=total_rf_mos_lvt
include "./crn40lp_2d5_v1d3.scs" section=global_rfmos_25ud18
include "./crn40lp_2d5_v1d3.scs" section=tt_rfmos_25ud18
include "./crn40lp_2d5_v1d3.scs" section=total_rf_mos_25ud18
include "./crn40lp_2d5_v1d3.scs" section=global_rfmos_25
include "./crn40lp_2d5_v1d3.scs" section=tt_rfmos_25
include "./crn40lp_2d5_v1d3.scs" section=total_rf_mos_25
include "./crn40lp_2d5_v1d3.scs" section=global_rfmos_25od33
include "./crn40lp_2d5_v1d3.scs" section=tt_rfmos_25od33
include "./crn40lp_2d5_v1d3.scs" section=total_rf_mos_25od33
include "./crn40lp_2d5_v1d3.scs" section=tt_rfmvar
include "./crn40lp_2d5_v1d3.scs" section=tt_rfmvar_25
include "./crn40lp_2d5_v1d3.scs" section=stat
include "./crn40lp_2d5_v1d3.scs" section=global
include "./crn40lp_2d5_v1d3.scs" section=tt
include "./crn40lp_2d5_v1d3.scs" section=global_hvt
include "./crn40lp_2d5_v1d3.scs" section=tt_hvt
include "./crn40lp_2d5_v1d3.scs" section=global_lvt
include "./crn40lp_2d5_v1d3.scs" section=tt_lvt
include "./crn40lp_2d5_v1d3.scs" section=global_25
include "./crn40lp_2d5_v1d3.scs" section=tt_25
include "./crn40lp_2d5_v1d3.scs" section=global_25ud18
include "./crn40lp_2d5_v1d3.scs" section=tt_25ud18
include "./crn40lp_2d5_v1d3.scs" section=global_25od33
include "./crn40lp_2d5_v1d3.scs" section=tt_25od33
include "./crn40lp_2d5_v1d3.scs" section=global_na
include "./crn40lp_2d5_v1d3.scs" section=tt_na
include "./crn40lp_2d5_v1d3.scs" section=global_na25
include "./crn40lp_2d5_v1d3.scs" section=tt_na25
include "./crn40lp_2d5_v1d3.scs" section=global_na25ud18
include "./crn40lp_2d5_v1d3.scs" section=tt_na25ud18
include "./crn40lp_2d5_v1d3.scs" section=global_na25od33
include "./crn40lp_2d5_v1d3.scs" section=tt_na25od33
include "./crn40lp_2d5_v1d3.scs" section=total
include "./crn40lp_2d5_v1d3.scs" section=total_hvt
include "./crn40lp_2d5_v1d3.scs" section=total_lvt
include "./crn40lp_2d5_v1d3.scs" section=total_25
include "./crn40lp_2d5_v1d3.scs" section=total_25ud18
include "./crn40lp_2d5_v1d3.scs" section=total_25od33
include "./crn40lp_2d5_v1d3.scs" section=total_na
include "./crn40lp_2d5_v1d3.scs" section=total_na25
include "./crn40lp_2d5_v1d3.scs" section=total_na25ud18
include "./crn40lp_2d5_v1d3.scs" section=total_na25od33
include "./crn40lp_2d5_v1d3.scs" section=tt_mos_cap
include "./crn40lp_2d5_v1d3.scs" section=tt_mos_cap_25
parOpt options redefinedparams=ignore
parameters totalflag_mos_rf=0
parameters totalflag_mos_rf_hvt=0
parameters totalflag_mos_rf_lvt=0
parameters totalflag_mos_rf_25ud18=0
parameters totalflag_mos_rf_25=0
parameters totalflag_mos_rf_25od33=0
parameters totalflag_mos=0
parameters totalflag_mos_hvt=0
parameters totalflag_mos_lvt=0
parameters totalflag_mos_25=0
parameters totalflag_mos_25ud18=0
parameters totalflag_mos_25od33=0
parameters totalflag_mos_na=0
parameters totalflag_mos_na25=0
parameters totalflag_mos_na25ud18=0
parameters totalflag_mos_na25od33=0
parameters globalflag_mos_rf=0
parameters globalflag_mos_rf_hvt=0
parameters globalflag_mos_rf_lvt=0
parameters globalflag_mos_rf_25ud18=0
parameters globalflag_mos_rf_25=0
parameters globalflag_mos_rf_25od33=0
parameters globalflag_mos=0
parameters globalflag_mos_hvt=0
parameters globalflag_mos_lvt=0
parameters globalflag_mos_25=0
parameters globalflag_mos_25ud18=0
parameters globalflag_mos_25od33=0
parameters globalflag_mos_na=0
parameters globalflag_mos_na25=0
parameters globalflag_mos_na25ud18=0
parameters globalflag_mos_na25od33=0
endsection localmconly_mos_moscap

section globalmc_localmc_mos_moscap
setscale options scalefactor=0.9
include "./crn40lp_2d5_v1d3.scs" section=global_rfmos
include "./crn40lp_2d5_v1d3.scs" section=tt_rfmos
include "./crn40lp_2d5_v1d3.scs" section=total_rf_mos
include "./crn40lp_2d5_v1d3.scs" section=global_rfmos_hvt
include "./crn40lp_2d5_v1d3.scs" section=tt_rfmos_hvt
include "./crn40lp_2d5_v1d3.scs" section=total_rf_mos_hvt
include "./crn40lp_2d5_v1d3.scs" section=global_rfmos_lvt
include "./crn40lp_2d5_v1d3.scs" section=tt_rfmos_lvt
include "./crn40lp_2d5_v1d3.scs" section=total_rf_mos_lvt
include "./crn40lp_2d5_v1d3.scs" section=global_rfmos_25ud18
include "./crn40lp_2d5_v1d3.scs" section=tt_rfmos_25ud18
include "./crn40lp_2d5_v1d3.scs" section=total_rf_mos_25ud18
include "./crn40lp_2d5_v1d3.scs" section=global_rfmos_25
include "./crn40lp_2d5_v1d3.scs" section=tt_rfmos_25
include "./crn40lp_2d5_v1d3.scs" section=total_rf_mos_25
include "./crn40lp_2d5_v1d3.scs" section=global_rfmos_25od33
include "./crn40lp_2d5_v1d3.scs" section=tt_rfmos_25od33
include "./crn40lp_2d5_v1d3.scs" section=total_rf_mos_25od33
include "./crn40lp_2d5_v1d3.scs" section=global_rfmvar
include "./crn40lp_2d5_v1d3.scs" section=global_rfmvar_25
include "./crn40lp_2d5_v1d3.scs" section=stat
include "./crn40lp_2d5_v1d3.scs" section=global
include "./crn40lp_2d5_v1d3.scs" section=tt
include "./crn40lp_2d5_v1d3.scs" section=global_hvt
include "./crn40lp_2d5_v1d3.scs" section=tt_hvt
include "./crn40lp_2d5_v1d3.scs" section=global_lvt
include "./crn40lp_2d5_v1d3.scs" section=tt_lvt
include "./crn40lp_2d5_v1d3.scs" section=global_25
include "./crn40lp_2d5_v1d3.scs" section=tt_25
include "./crn40lp_2d5_v1d3.scs" section=global_25ud18
include "./crn40lp_2d5_v1d3.scs" section=tt_25ud18
include "./crn40lp_2d5_v1d3.scs" section=global_25od33
include "./crn40lp_2d5_v1d3.scs" section=tt_25od33
include "./crn40lp_2d5_v1d3.scs" section=global_na
include "./crn40lp_2d5_v1d3.scs" section=tt_na
include "./crn40lp_2d5_v1d3.scs" section=global_na25
include "./crn40lp_2d5_v1d3.scs" section=tt_na25
include "./crn40lp_2d5_v1d3.scs" section=global_na25ud18
include "./crn40lp_2d5_v1d3.scs" section=tt_na25ud18
include "./crn40lp_2d5_v1d3.scs" section=global_na25od33
include "./crn40lp_2d5_v1d3.scs" section=tt_na25od33
include "./crn40lp_2d5_v1d3.scs" section=total
include "./crn40lp_2d5_v1d3.scs" section=total_hvt
include "./crn40lp_2d5_v1d3.scs" section=total_lvt
include "./crn40lp_2d5_v1d3.scs" section=total_25
include "./crn40lp_2d5_v1d3.scs" section=total_25ud18
include "./crn40lp_2d5_v1d3.scs" section=total_25od33
include "./crn40lp_2d5_v1d3.scs" section=total_na
include "./crn40lp_2d5_v1d3.scs" section=total_na25
include "./crn40lp_2d5_v1d3.scs" section=total_na25ud18
include "./crn40lp_2d5_v1d3.scs" section=total_na25od33
include "./crn40lp_2d5_v1d3.scs" section=global_mos_cap
include "./crn40lp_2d5_v1d3.scs" section=global_mos_cap_25
parOpt options redefinedparams=ignore
parameters totalflag_mos_rf=0
parameters totalflag_mos_rf_hvt=0
parameters totalflag_mos_rf_lvt=0
parameters totalflag_mos_rf_25ud18=0
parameters totalflag_mos_rf_25=0
parameters totalflag_mos_rf_25od33=0
parameters totalflag_mos=0
parameters totalflag_mos_hvt=0
parameters totalflag_mos_lvt=0
parameters totalflag_mos_25=0
parameters totalflag_mos_25ud18=0
parameters totalflag_mos_25od33=0
parameters totalflag_mos_na=0
parameters totalflag_mos_na25=0
parameters totalflag_mos_na25ud18=0
parameters totalflag_mos_na25od33=0
endsection globalmc_localmc_mos_moscap

section tt_res_bip_dio_disres
setscale options scalefactor=0.9
include "./crn40lp_2d5_v1d3.scs" section=tt_rfres_sa
include "./crn40lp_2d5_v1d3.scs" section=tt_rfres_rpo
include "./crn40lp_2d5_v1d3.scs" section=tt_dio_hia_rf
include "./crn40lp_2d5_v1d3.scs" section=tt_lowcpad
include "./crn40lp_2d5_v1d3.scs" section=tt_bip
include "./crn40lp_2d5_v1d3.scs" section=stat_mis_bip
include "./crn40lp_2d5_v1d3.scs" section=tt_bip_npn
include "./crn40lp_2d5_v1d3.scs" section=stat_mis_bip_npn
include "./crn40lp_2d5_v1d3.scs" section=tt_dio
include "./crn40lp_2d5_v1d3.scs" section=tt_dio_hvt
include "./crn40lp_2d5_v1d3.scs" section=tt_dio_lvt
include "./crn40lp_2d5_v1d3.scs" section=tt_dio_25
include "./crn40lp_2d5_v1d3.scs" section=tt_dio_25ud18
include "./crn40lp_2d5_v1d3.scs" section=tt_dio_25od33
include "./crn40lp_2d5_v1d3.scs" section=tt_dio_na
include "./crn40lp_2d5_v1d3.scs" section=tt_dio_na25
include "./crn40lp_2d5_v1d3.scs" section=tt_dio_na25ud18
include "./crn40lp_2d5_v1d3.scs" section=tt_dio_na25od33
include "./crn40lp_2d5_v1d3.scs" section=tt_dio_dnw
include "./crn40lp_2d5_v1d3.scs" section=tt_dio_esd
include "./crn40lp_2d5_v1d3.scs" section=tt_res
include "./crn40lp_2d5_v1d3.scs" section=tt_disres
parOpt options redefinedparams=ignore
parameters mismatchflag_bip=0
parameters mismatchflag_bip_npn=0
parameters mismatchflag_res=0
parameters mismatchflag_disres=0
parameters mismatchflag_rfres_sa=0
parameters mismatchflag_rfres_rpo=0
endsection tt_res_bip_dio_disres

section ss_res_bip_dio_disres
setscale options scalefactor=0.9
include "./crn40lp_2d5_v1d3.scs" section=ss_rfres_sa
include "./crn40lp_2d5_v1d3.scs" section=ss_rfres_rpo
include "./crn40lp_2d5_v1d3.scs" section=ss_dio_hia_rf
include "./crn40lp_2d5_v1d3.scs" section=ss_lowcpad
include "./crn40lp_2d5_v1d3.scs" section=ss_bip
include "./crn40lp_2d5_v1d3.scs" section=stat_mis_bip
include "./crn40lp_2d5_v1d3.scs" section=ss_bip_npn
include "./crn40lp_2d5_v1d3.scs" section=stat_mis_bip_npn
include "./crn40lp_2d5_v1d3.scs" section=ss_dio
include "./crn40lp_2d5_v1d3.scs" section=ss_dio_hvt
include "./crn40lp_2d5_v1d3.scs" section=ss_dio_lvt
include "./crn40lp_2d5_v1d3.scs" section=ss_dio_25
include "./crn40lp_2d5_v1d3.scs" section=ss_dio_25ud18
include "./crn40lp_2d5_v1d3.scs" section=ss_dio_25od33
include "./crn40lp_2d5_v1d3.scs" section=ss_dio_na
include "./crn40lp_2d5_v1d3.scs" section=ss_dio_na25
include "./crn40lp_2d5_v1d3.scs" section=ss_dio_na25ud18
include "./crn40lp_2d5_v1d3.scs" section=ss_dio_na25od33
include "./crn40lp_2d5_v1d3.scs" section=ss_dio_dnw
include "./crn40lp_2d5_v1d3.scs" section=ss_dio_esd
include "./crn40lp_2d5_v1d3.scs" section=ss_res
include "./crn40lp_2d5_v1d3.scs" section=ss_disres
parOpt options redefinedparams=ignore
parameters mismatchflag_bip=0
parameters mismatchflag_bip_npn=0
parameters mismatchflag_res=0
parameters mismatchflag_disres=0
parameters mismatchflag_rfres_sa=0
parameters mismatchflag_rfres_rpo=0
endsection ss_res_bip_dio_disres

section ff_res_bip_dio_disres
setscale options scalefactor=0.9
include "./crn40lp_2d5_v1d3.scs" section=ff_rfres_sa
include "./crn40lp_2d5_v1d3.scs" section=ff_rfres_rpo
include "./crn40lp_2d5_v1d3.scs" section=ff_dio_hia_rf
include "./crn40lp_2d5_v1d3.scs" section=ff_lowcpad
include "./crn40lp_2d5_v1d3.scs" section=ff_bip
include "./crn40lp_2d5_v1d3.scs" section=stat_mis_bip
include "./crn40lp_2d5_v1d3.scs" section=ff_bip_npn
include "./crn40lp_2d5_v1d3.scs" section=stat_mis_bip_npn
include "./crn40lp_2d5_v1d3.scs" section=ff_dio
include "./crn40lp_2d5_v1d3.scs" section=ff_dio_hvt
include "./crn40lp_2d5_v1d3.scs" section=ff_dio_lvt
include "./crn40lp_2d5_v1d3.scs" section=ff_dio_25
include "./crn40lp_2d5_v1d3.scs" section=ff_dio_25ud18
include "./crn40lp_2d5_v1d3.scs" section=ff_dio_25od33
include "./crn40lp_2d5_v1d3.scs" section=ff_dio_na
include "./crn40lp_2d5_v1d3.scs" section=ff_dio_na25
include "./crn40lp_2d5_v1d3.scs" section=ff_dio_na25ud18
include "./crn40lp_2d5_v1d3.scs" section=ff_dio_na25od33
include "./crn40lp_2d5_v1d3.scs" section=ff_dio_dnw
include "./crn40lp_2d5_v1d3.scs" section=ff_dio_esd
include "./crn40lp_2d5_v1d3.scs" section=ff_res
include "./crn40lp_2d5_v1d3.scs" section=ff_disres
parOpt options redefinedparams=ignore
parameters mismatchflag_bip=0
parameters mismatchflag_bip_npn=0
parameters mismatchflag_res=0
parameters mismatchflag_disres=0
parameters mismatchflag_rfres_sa=0
parameters mismatchflag_rfres_rpo=0
endsection ff_res_bip_dio_disres

section ttglobalcorner_localmc_res_bip_dio_disres
setscale options scalefactor=0.9
include "./crn40lp_2d5_v1d3.scs" section=tt_rfres_sa
include "./crn40lp_2d5_v1d3.scs" section=stat_mis_rfres_sa
include "./crn40lp_2d5_v1d3.scs" section=tt_rfres_rpo
include "./crn40lp_2d5_v1d3.scs" section=stat_mis_rfres_rpo
include "./crn40lp_2d5_v1d3.scs" section=tt_dio_hia_rf
include "./crn40lp_2d5_v1d3.scs" section=tt_lowcpad
include "./crn40lp_2d5_v1d3.scs" section=tt_bip
include "./crn40lp_2d5_v1d3.scs" section=stat_mis_bip
include "./crn40lp_2d5_v1d3.scs" section=tt_bip_npn
include "./crn40lp_2d5_v1d3.scs" section=stat_mis_bip_npn
include "./crn40lp_2d5_v1d3.scs" section=tt_dio
include "./crn40lp_2d5_v1d3.scs" section=tt_dio_hvt
include "./crn40lp_2d5_v1d3.scs" section=tt_dio_lvt
include "./crn40lp_2d5_v1d3.scs" section=tt_dio_25
include "./crn40lp_2d5_v1d3.scs" section=tt_dio_25ud18
include "./crn40lp_2d5_v1d3.scs" section=tt_dio_25od33
include "./crn40lp_2d5_v1d3.scs" section=tt_dio_na
include "./crn40lp_2d5_v1d3.scs" section=tt_dio_na25
include "./crn40lp_2d5_v1d3.scs" section=tt_dio_na25ud18
include "./crn40lp_2d5_v1d3.scs" section=tt_dio_na25od33
include "./crn40lp_2d5_v1d3.scs" section=tt_dio_dnw
include "./crn40lp_2d5_v1d3.scs" section=tt_dio_esd
include "./crn40lp_2d5_v1d3.scs" section=tt_res
include "./crn40lp_2d5_v1d3.scs" section=stat_mis_res
include "./crn40lp_2d5_v1d3.scs" section=tt_disres
include "./crn40lp_2d5_v1d3.scs" section=stat_mis_disres
endsection ttglobalcorner_localmc_res_bip_dio_disres

section ssglobalcorner_localmc_res_bip_dio_disres
setscale options scalefactor=0.9
include "./crn40lp_2d5_v1d3.scs" section=ss_rfres_sa
include "./crn40lp_2d5_v1d3.scs" section=stat_mis_rfres_sa
include "./crn40lp_2d5_v1d3.scs" section=ss_rfres_rpo
include "./crn40lp_2d5_v1d3.scs" section=stat_mis_rfres_rpo
include "./crn40lp_2d5_v1d3.scs" section=ss_dio_hia_rf
include "./crn40lp_2d5_v1d3.scs" section=ss_lowcpad
include "./crn40lp_2d5_v1d3.scs" section=ss_bip
include "./crn40lp_2d5_v1d3.scs" section=stat_mis_bip
include "./crn40lp_2d5_v1d3.scs" section=ss_bip_npn
include "./crn40lp_2d5_v1d3.scs" section=stat_mis_bip_npn
include "./crn40lp_2d5_v1d3.scs" section=ss_dio
include "./crn40lp_2d5_v1d3.scs" section=ss_dio_hvt
include "./crn40lp_2d5_v1d3.scs" section=ss_dio_lvt
include "./crn40lp_2d5_v1d3.scs" section=ss_dio_25
include "./crn40lp_2d5_v1d3.scs" section=ss_dio_25ud18
include "./crn40lp_2d5_v1d3.scs" section=ss_dio_25od33
include "./crn40lp_2d5_v1d3.scs" section=ss_dio_na
include "./crn40lp_2d5_v1d3.scs" section=ss_dio_na25
include "./crn40lp_2d5_v1d3.scs" section=ss_dio_na25ud18
include "./crn40lp_2d5_v1d3.scs" section=ss_dio_na25od33
include "./crn40lp_2d5_v1d3.scs" section=ss_dio_dnw
include "./crn40lp_2d5_v1d3.scs" section=ss_dio_esd
include "./crn40lp_2d5_v1d3.scs" section=ss_res
include "./crn40lp_2d5_v1d3.scs" section=stat_mis_res
include "./crn40lp_2d5_v1d3.scs" section=ss_disres
include "./crn40lp_2d5_v1d3.scs" section=stat_mis_disres
endsection ssglobalcorner_localmc_res_bip_dio_disres

section ffglobalcorner_localmc_res_bip_dio_disres
setscale options scalefactor=0.9
include "./crn40lp_2d5_v1d3.scs" section=ff_rfres_sa
include "./crn40lp_2d5_v1d3.scs" section=stat_mis_rfres_sa
include "./crn40lp_2d5_v1d3.scs" section=ff_rfres_rpo
include "./crn40lp_2d5_v1d3.scs" section=stat_mis_rfres_rpo
include "./crn40lp_2d5_v1d3.scs" section=ff_dio_hia_rf
include "./crn40lp_2d5_v1d3.scs" section=ff_lowcpad
include "./crn40lp_2d5_v1d3.scs" section=ff_bip
include "./crn40lp_2d5_v1d3.scs" section=stat_mis_bip
include "./crn40lp_2d5_v1d3.scs" section=ff_bip_npn
include "./crn40lp_2d5_v1d3.scs" section=stat_mis_bip_npn
include "./crn40lp_2d5_v1d3.scs" section=ff_dio
include "./crn40lp_2d5_v1d3.scs" section=ff_dio_hvt
include "./crn40lp_2d5_v1d3.scs" section=ff_dio_lvt
include "./crn40lp_2d5_v1d3.scs" section=ff_dio_25
include "./crn40lp_2d5_v1d3.scs" section=ff_dio_25ud18
include "./crn40lp_2d5_v1d3.scs" section=ff_dio_25od33
include "./crn40lp_2d5_v1d3.scs" section=ff_dio_na
include "./crn40lp_2d5_v1d3.scs" section=ff_dio_na25
include "./crn40lp_2d5_v1d3.scs" section=ff_dio_na25ud18
include "./crn40lp_2d5_v1d3.scs" section=ff_dio_na25od33
include "./crn40lp_2d5_v1d3.scs" section=ff_dio_dnw
include "./crn40lp_2d5_v1d3.scs" section=ff_dio_esd
include "./crn40lp_2d5_v1d3.scs" section=ff_res
include "./crn40lp_2d5_v1d3.scs" section=stat_mis_res
include "./crn40lp_2d5_v1d3.scs" section=ff_disres
include "./crn40lp_2d5_v1d3.scs" section=stat_mis_disres
endsection ffglobalcorner_localmc_res_bip_dio_disres

section localmconly_res_bip_dio_disres
setscale options scalefactor=0.9
include "./crn40lp_2d5_v1d3.scs" section=tt_rfres_sa
include "./crn40lp_2d5_v1d3.scs" section=stat_mis_rfres_sa
include "./crn40lp_2d5_v1d3.scs" section=tt_rfres_rpo
include "./crn40lp_2d5_v1d3.scs" section=stat_mis_rfres_rpo
include "./crn40lp_2d5_v1d3.scs" section=tt_dio_hia_rf
include "./crn40lp_2d5_v1d3.scs" section=tt_lowcpad
include "./crn40lp_2d5_v1d3.scs" section=tt_bip
include "./crn40lp_2d5_v1d3.scs" section=stat_mis_bip
include "./crn40lp_2d5_v1d3.scs" section=tt_bip_npn
include "./crn40lp_2d5_v1d3.scs" section=stat_mis_bip_npn
include "./crn40lp_2d5_v1d3.scs" section=tt_dio
include "./crn40lp_2d5_v1d3.scs" section=tt_dio_hvt
include "./crn40lp_2d5_v1d3.scs" section=tt_dio_lvt
include "./crn40lp_2d5_v1d3.scs" section=tt_dio_25
include "./crn40lp_2d5_v1d3.scs" section=tt_dio_25ud18
include "./crn40lp_2d5_v1d3.scs" section=tt_dio_25od33
include "./crn40lp_2d5_v1d3.scs" section=tt_dio_na
include "./crn40lp_2d5_v1d3.scs" section=tt_dio_na25
include "./crn40lp_2d5_v1d3.scs" section=tt_dio_na25ud18
include "./crn40lp_2d5_v1d3.scs" section=tt_dio_na25od33
include "./crn40lp_2d5_v1d3.scs" section=tt_dio_dnw
include "./crn40lp_2d5_v1d3.scs" section=tt_dio_esd
include "./crn40lp_2d5_v1d3.scs" section=tt_res
include "./crn40lp_2d5_v1d3.scs" section=stat_mis_res
include "./crn40lp_2d5_v1d3.scs" section=tt_disres
include "./crn40lp_2d5_v1d3.scs" section=stat_mis_disres
endsection localmconly_res_bip_dio_disres

section globalmc_localmc_res_bip_dio_disres
setscale options scalefactor=0.9
include "./crn40lp_2d5_v1d3.scs" section=total_rfres_sa
include "./crn40lp_2d5_v1d3.scs" section=stat_mis_rfres_sa
include "./crn40lp_2d5_v1d3.scs" section=total_rfres_rpo
include "./crn40lp_2d5_v1d3.scs" section=stat_mis_rfres_rpo
include "./crn40lp_2d5_v1d3.scs" section=global_dio_hia_rf
include "./crn40lp_2d5_v1d3.scs" section=tt_lowcpad
include "./crn40lp_2d5_v1d3.scs" section=stat_res
include "./crn40lp_2d5_v1d3.scs" section=stat_bip_dio
include "./crn40lp_2d5_v1d3.scs" section=total_bip
include "./crn40lp_2d5_v1d3.scs" section=stat_mis_bip
include "./crn40lp_2d5_v1d3.scs" section=total_bip_npn
include "./crn40lp_2d5_v1d3.scs" section=stat_mis_bip_npn
include "./crn40lp_2d5_v1d3.scs" section=global_dio
include "./crn40lp_2d5_v1d3.scs" section=global_dio_hvt
include "./crn40lp_2d5_v1d3.scs" section=global_dio_lvt
include "./crn40lp_2d5_v1d3.scs" section=global_dio_25
include "./crn40lp_2d5_v1d3.scs" section=global_dio_25ud18
include "./crn40lp_2d5_v1d3.scs" section=global_dio_25od33
include "./crn40lp_2d5_v1d3.scs" section=global_dio_na
include "./crn40lp_2d5_v1d3.scs" section=global_dio_na25
include "./crn40lp_2d5_v1d3.scs" section=global_dio_na25ud18
include "./crn40lp_2d5_v1d3.scs" section=global_dio_na25od33
include "./crn40lp_2d5_v1d3.scs" section=global_dio_dnw
include "./crn40lp_2d5_v1d3.scs" section=global_dio_esd
include "./crn40lp_2d5_v1d3.scs" section=total_res
include "./crn40lp_2d5_v1d3.scs" section=stat_mis_res
include "./crn40lp_2d5_v1d3.scs" section=total_disres
include "./crn40lp_2d5_v1d3.scs" section=stat_mis_disres
endsection globalmc_localmc_res_bip_dio_disres

section tt_rtmom
setscale options scalefactor=0.9
include "./crn40lp_2d5_v1d3.scs" section=tt_rfrtmom
include "./crn40lp_2d5_v1d3.scs" section=tt_rffmom
include "./crn40lp_2d5_v1d3.scs" section=tt_rtmom
include "./crn40lp_2d5_v1d3.scs" section=tt_fmom
parOpt options redefinedparams=ignore
parameters mismatchflag_rtmom=0
parameters mismatchflag_rfrtmom=0
parameters mismatchflag_fmom=0
parameters mismatchflag_rffmom=0
endsection tt_rtmom

section ss_rtmom
setscale options scalefactor=0.9
include "./crn40lp_2d5_v1d3.scs" section=ss_rfrtmom
include "./crn40lp_2d5_v1d3.scs" section=ss_rffmom
include "./crn40lp_2d5_v1d3.scs" section=ss_rtmom
include "./crn40lp_2d5_v1d3.scs" section=ss_fmom
parOpt options redefinedparams=ignore
parameters mismatchflag_rtmom=0
parameters mismatchflag_rfrtmom=0
parameters mismatchflag_fmom=0
parameters mismatchflag_rffmom=0
endsection ss_rtmom

section ff_rtmom
setscale options scalefactor=0.9
include "./crn40lp_2d5_v1d3.scs" section=ff_rfrtmom
include "./crn40lp_2d5_v1d3.scs" section=ff_rffmom
include "./crn40lp_2d5_v1d3.scs" section=ff_rtmom
include "./crn40lp_2d5_v1d3.scs" section=ff_fmom
parOpt options redefinedparams=ignore
parameters mismatchflag_rtmom=0
parameters mismatchflag_rfrtmom=0
parameters mismatchflag_fmom=0
parameters mismatchflag_rffmom=0
endsection ff_rtmom

section ttglobalcorner_localmc_rtmom
setscale options scalefactor=0.9
include "./crn40lp_2d5_v1d3.scs" section=tt_rfrtmom
include "./crn40lp_2d5_v1d3.scs" section=stat_mis_rfrtmom
include "./crn40lp_2d5_v1d3.scs" section=tt_rffmom
include "./crn40lp_2d5_v1d3.scs" section=stat_mis_rffmom
include "./crn40lp_2d5_v1d3.scs" section=tt_rtmom
include "./crn40lp_2d5_v1d3.scs" section=stat_mis_rtmom
include "./crn40lp_2d5_v1d3.scs" section=tt_fmom
include "./crn40lp_2d5_v1d3.scs" section=stat_mis_fmom
endsection ttglobalcorner_localmc_rtmom

section ssglobalcorner_localmc_rtmom
setscale options scalefactor=0.9
include "./crn40lp_2d5_v1d3.scs" section=ss_rfrtmom
include "./crn40lp_2d5_v1d3.scs" section=stat_mis_rfrtmom
include "./crn40lp_2d5_v1d3.scs" section=ss_rffmom
include "./crn40lp_2d5_v1d3.scs" section=stat_mis_rffmom
include "./crn40lp_2d5_v1d3.scs" section=ss_rtmom
include "./crn40lp_2d5_v1d3.scs" section=stat_mis_rtmom
include "./crn40lp_2d5_v1d3.scs" section=ss_fmom
include "./crn40lp_2d5_v1d3.scs" section=stat_mis_fmom
endsection ssglobalcorner_localmc_rtmom

section ffglobalcorner_localmc_rtmom
setscale options scalefactor=0.9
include "./crn40lp_2d5_v1d3.scs" section=ff_rfrtmom
include "./crn40lp_2d5_v1d3.scs" section=stat_mis_rfrtmom
include "./crn40lp_2d5_v1d3.scs" section=ff_rffmom
include "./crn40lp_2d5_v1d3.scs" section=stat_mis_rffmom
include "./crn40lp_2d5_v1d3.scs" section=ff_rtmom
include "./crn40lp_2d5_v1d3.scs" section=stat_mis_rtmom
include "./crn40lp_2d5_v1d3.scs" section=ff_fmom
include "./crn40lp_2d5_v1d3.scs" section=stat_mis_fmom
endsection ffglobalcorner_localmc_rtmom

section localmconly_rtmom
setscale options scalefactor=0.9
include "./crn40lp_2d5_v1d3.scs" section=tt_rfrtmom
include "./crn40lp_2d5_v1d3.scs" section=stat_mis_rfrtmom
include "./crn40lp_2d5_v1d3.scs" section=tt_rffmom
include "./crn40lp_2d5_v1d3.scs" section=stat_mis_rffmom
include "./crn40lp_2d5_v1d3.scs" section=tt_rtmom
include "./crn40lp_2d5_v1d3.scs" section=stat_mis_rtmom
include "./crn40lp_2d5_v1d3.scs" section=tt_fmom
include "./crn40lp_2d5_v1d3.scs" section=stat_mis_fmom
endsection localmconly_rtmom

section globalmc_localmc_rtmom
setscale options scalefactor=0.9
include "./crn40lp_2d5_v1d3.scs" section=total_rfrtmom
include "./crn40lp_2d5_v1d3.scs" section=stat_mis_rfrtmom
include "./crn40lp_2d5_v1d3.scs" section=total_rffmom
include "./crn40lp_2d5_v1d3.scs" section=stat_mis_rffmom
include "./crn40lp_2d5_v1d3.scs" section=stat_mom
include "./crn40lp_2d5_v1d3.scs" section=total_rtmom
include "./crn40lp_2d5_v1d3.scs" section=stat_mis_rtmom
include "./crn40lp_2d5_v1d3.scs" section=total_fmom
include "./crn40lp_2d5_v1d3.scs" section=stat_mis_fmom
endsection globalmc_localmc_rtmom

section tt_ind_jvar
setscale options scalefactor=0.9
include "./crn40lp_2d5_v1d3.scs" section=tt_rfjvar
include "./crn40lp_2d5_v1d3.scs" section=tt_rftl
include "./crn40lp_2d5_v1d3.scs" section=tt_rfind
endsection tt_ind_jvar

section ss_ind_jvar
setscale options scalefactor=0.9
include "./crn40lp_2d5_v1d3.scs" section=ss_rfjvar
include "./crn40lp_2d5_v1d3.scs" section=ss_rftl
include "./crn40lp_2d5_v1d3.scs" section=ss_rfind
endsection ss_ind_jvar

section ff_ind_jvar
setscale options scalefactor=0.9
include "./crn40lp_2d5_v1d3.scs" section=ff_rfjvar
include "./crn40lp_2d5_v1d3.scs" section=ff_rftl
include "./crn40lp_2d5_v1d3.scs" section=ff_rfind
endsection ff_ind_jvar

section ttglobalcorner_localmc_ind_jvar
setscale options scalefactor=0.9
include "./crn40lp_2d5_v1d3.scs" section=tt_rfjvar
include "./crn40lp_2d5_v1d3.scs" section=tt_rftl
include "./crn40lp_2d5_v1d3.scs" section=tt_rfind
endsection ttglobalcorner_localmc_ind_jvar

section ssglobalcorner_localmc_ind_jvar
setscale options scalefactor=0.9
include "./crn40lp_2d5_v1d3.scs" section=ss_rfjvar
include "./crn40lp_2d5_v1d3.scs" section=ss_rftl
include "./crn40lp_2d5_v1d3.scs" section=ss_rfind
endsection ssglobalcorner_localmc_ind_jvar

section ffglobalcorner_localmc_ind_jvar
setscale options scalefactor=0.9
include "./crn40lp_2d5_v1d3.scs" section=ff_rfjvar
include "./crn40lp_2d5_v1d3.scs" section=ff_rftl
include "./crn40lp_2d5_v1d3.scs" section=ff_rfind
endsection ffglobalcorner_localmc_ind_jvar

section localmconly_ind_jvar
setscale options scalefactor=0.9
include "./crn40lp_2d5_v1d3.scs" section=tt_rfjvar
include "./crn40lp_2d5_v1d3.scs" section=tt_rftl
include "./crn40lp_2d5_v1d3.scs" section=tt_rfind
endsection localmconly_ind_jvar

section globalmc_localmc_ind_jvar
setscale options scalefactor=0.9
include "./crn40lp_2d5_v1d3.scs" section=stat_jvar
include "./crn40lp_2d5_v1d3.scs" section=global_rfjvar
include "./crn40lp_2d5_v1d3.scs" section=stat_rftl
include "./crn40lp_2d5_v1d3.scs" section=total_rftl
include "./crn40lp_2d5_v1d3.scs" section=stat_ind
include "./crn40lp_2d5_v1d3.scs" section=global_rfind
endsection globalmc_localmc_ind_jvar
