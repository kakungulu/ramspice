section pre_simu
setscale options scalefactor=0.9
parOpt options redefinedparams=ignore
parameters ccoflag_hv25_snw_spw=1
parameters rgflag_hv25_snw_spw=1
endsection pre_simu

section tt_hv25
setscale options scalefactor=0.9
include "cln40lp_hv_2d5_lk_v1d1_1.scs" section=tt_hv25_snw_spw
parOpt options redefinedparams=ignore
endsection tt_hv25

section ss_hv25
setscale options scalefactor=0.9
include "cln40lp_hv_2d5_lk_v1d1_1.scs" section=ss_hv25_snw_spw
parOpt options redefinedparams=ignore
endsection ss_hv25

section ff_hv25
setscale options scalefactor=0.9
include "cln40lp_hv_2d5_lk_v1d1_1.scs" section=ff_hv25_snw_spw
parOpt options redefinedparams=ignore
endsection ff_hv25

section sf_hv25
setscale options scalefactor=0.9
include "cln40lp_hv_2d5_lk_v1d1_1.scs" section=sf_hv25_snw_spw
parOpt options redefinedparams=ignore
endsection sf_hv25

section fs_hv25
setscale options scalefactor=0.9
include "cln40lp_hv_2d5_lk_v1d1_1.scs" section=fs_hv25_snw_spw
parOpt options redefinedparams=ignore
endsection fs_hv25
