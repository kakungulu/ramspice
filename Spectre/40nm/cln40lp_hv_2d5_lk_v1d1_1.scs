//
simulator lang=spectre insensitive=yes
library tsmclib
//   **********************************************
//   *             TSMC SPICE MODEL               *
//   **********************************************
//
//     PROCESS :  0.040um LOGIC SALICIDE Low-K IMD (Vg=2.5V/Vd=5V) (CLN40LP HVMOS)
//     MODEL   :  BSIM4 ( V4.5 )
//     DOC. NO.:  T-N40-CL-SP-034
//     VERSION :  V1d1_1
//     DATE    :  Nov. 16, 2009
//     SPECTRE VERSION : 7.1.0.048
// *****************************************************************************
//   Updated History:
//   *
//      Date    Version
//   *
//   1. 12/11/08 V1d0_1p1  Newly created Si based HVMOS model
//   *
//                         LOD and WPE are not included
//   2. 05/27/09 V1d0_1    Model copy from V1d0_1p1 (Official release)
//   *
//   3. 11/06/09 V1d1_1p1  Update AC model basing on new silicon data
//   *
//   4. 11/16/09 V1d1_1    Model copy from V1d1_1p1(Official release)
//   *
// *****************************************************************************
// *****************************************************************************
//
//   *
//        THIS MODEL LIB CONTAINS :
//   *
//
//   *
//        1.LIB TT_hv25_snw_spw
//   *
//              SS_hv25_snw_spw
//   *
//              FF_hv25_snw_spw
//   *
//              SF_hv25_snw_spw
//   *
//              FS_hv25_snw_spw
//   *
//    ( 2.5V HVMOS devices for standard NW_HVNMOS and PW_HVPMOS with different
//  *
//      geometry and corner models)
//   *
// 									     *
// *****************************************************************************
//
//  NOTE:
//   1. All parasitics capacitances are removed from intrinsic model. The model
//  only
//      covers the intrinsic MOSFET. All parasitic components will be handled
//  by LPE.
//      For pre-layout simulation, contact-to-poly capacitance can be simulated
//  by
//      setting ccoflag_hv25_snw_spw=1.
//
//   2. Best approximation for gate resistance extraction is 1/3 of Rg, DC gate
//
//      resistance. Current LPE tools extract gate resistors from gate edge to
//  center
//      of gate. Error of 1/2 Rg methodology is less than 5% when W/L < 30.  It
//  is
//      recommended to split wide gate transistor to meet W/L < 30 for high precision
//
//      designs. For pre-layout simulation, Rg effect can be simulated by setting
//
//      rgflag_hv25_snw_spw=1
//
// **********************************************************************************

// ***********************    FLAG FOR CONTACT-POLY CAPACITANCE    *******************************
//
//  NOTE: *  1. The default value of ccoflag is 0, which means that the model
//  will exclude contact-to-poly
//      capacitance.  LPE tools should extract this capacitance during post-layout
//  simulation.
//   2. Users could set ccoflag to 1 for pre-layout simulation where contact-to-poly
//  capacitance
//      with maximum contact density is required.
//
// ***********************************************************************************************

section setup_hv25_snw_spw
parameters ccoflag_hv25_snw_spw=0
parameters rgflag_hv25_snw_spw=0
parameters sigma_factor_hv25_snw_spw=1

endsection setup_hv25_snw_spw

// **************************     LIBRARY OF TYPICAL CASE     ***************************

section tt_hv25_snw_spw
include "cln40lp_hv_2d5_lk_v1d1_1.scs" section=setup_hv25_snw_spw
parameters toxn_hv25_snw=5.7e-09
parameters dxln_hv25_snw=0
parameters dxwn_hv25_snw=0
parameters cjdn_hv25_snw=1.37e-4
parameters cjswdn_hv25_snw=5.26e-10
parameters cjswgdn_hv25_snw=6.43e-10
parameters cjsn_hv25_snw=1.063e-03
parameters cjswsn_hv25_snw=1.280e-10
parameters cjswgsn_hv25_snw=1.560e-10
parameters cgdon_hv25_snw=1e-12
parameters cgdln_hv25_snw=2.63e-9
parameters ddlcn_hv25_snw=2.36e-07
parameters cgson_hv25_snw=1.06035e-12
parameters cgsln_hv25_snw=2.37061e-10
parameters dvthn_hv25_snw=0
parameters dlvthn_hv25_snw=0
parameters dwvthn_hv25_snw=0
parameters dpvthn_hv25_snw=0
parameters du0n_hv25_snw=0
parameters dlu0n_hv25_snw=0
parameters dwu0n_hv25_snw=0
parameters dpu0n_hv25_snw=0
parameters dketan_hv25_snw=0
parameters dlketan_hv25_snw=0
parameters dwketan_hv25_snw=0
parameters dpketan_hv25_snw=0
parameters dnfactorn_hv25_snw=0
parameters dlnfactorn_hv25_snw=0
parameters dwnfactorn_hv25_snw=0
parameters dpnfactorn_hv25_snw=0
parameters dvsatn_hv25_snw=0
parameters dwvsatn_hv25_snw=0
parameters dk2n_hv25_snw=0
parameters dlk2n_hv25_snw=0
parameters dwk2n_hv25_snw=0
parameters dpk2n_hv25_snw=0
parameters deta0n_hv25_snw=0
parameters dweta0n_hv25_snw=0
parameters dagsn_hv25_snw=0
parameters dlagsn_hv25_snw=0
parameters dwagsn_hv25_snw=0
parameters dpagsn_hv25_snw=0
parameters dvoffn_hv25_snw=0
parameters dlvoffn_hv25_snw=0
parameters dwvoffn_hv25_snw=0
parameters dpvoffn_hv25_snw=0
parameters dcitn_hv25_snw=0
parameters dlcitn_hv25_snw=0
parameters dwcitn_hv25_snw=0
parameters dpcitn_hv25_snw=0
parameters duan_hv25_snw=0
parameters dluan_hv25_snw=0
parameters dwuan_hv25_snw=0
parameters dpuan_hv25_snw=0
parameters dubn_hv25_snw=0
parameters dlubn_hv25_snw=0
parameters dwubn_hv25_snw=0
parameters dpubn_hv25_snw=0
parameters djtsswgdn_hv25_snw=0
parameters djtsswgsn_hv25_snw=0
parameters dkt1n_hv25_snw=0
parameters dlkt1n_hv25_snw=0
parameters dwkt1n_hv25_snw=0
parameters dpkt1n_hv25_snw=0
parameters datn_hv25_snw=0
parameters dlatn_hv25_snw=0
parameters dwatn_hv25_snw=0
parameters dpatn_hv25_snw=0
parameters dagidln_hv25_snw=0
parameters dlagidln_hv25_snw=0
parameters dwagidln_hv25_snw=0
parameters dpagidln_hv25_snw=0
parameters dbgidln_hv25_snw=0
parameters dlbgidln_hv25_snw=0
parameters dwbgidln_hv25_snw=0
parameters dpbgidln_hv25_snw=0
parameters dnjtsswgn_hv25_snw=0
parameters ss_flag_hv25_snw_spw=0
parameters ff_flag_hv25_snw_spw=0
parameters sf_flag_hv25_snw_spw=0
parameters fs_flag_hv25_snw_spw=0
parameters cfn_hv25_snw=8.02e-11 + 6.99e-11 * ccoflag_hv25_snw_spw
parameters toxp_hv25_spw=6.13e-09
parameters dxlp_hv25_spw=0
parameters dxwp_hv25_spw=0
parameters cjdp_hv25_spw=5.93e-4
parameters cjswdp_hv25_spw=3.37e-10
parameters cjswgdp_hv25_spw=8.00e-10
parameters cjsp_hv25_spw=1.19000e-03
parameters cjswsp_hv25_spw=1.03000e-10
parameters cjswgsp_hv25_spw=1.09000e-10
parameters cgdop_hv25_spw=1.99e-10
parameters cgdlp_hv25_spw=8.25e-10
parameters ddlcp_hv25_spw=1.193e-07
parameters cgsop_hv25_spw=6.13160e-13
parameters cgslp_hv25_spw=3.34994e-10
parameters dvthp_hv25_spw=0
parameters dlvthp_hv25_spw=0
parameters dwvthp_hv25_spw=0
parameters dpvthp_hv25_spw=0
parameters du0p_hv25_spw=0
parameters dlu0p_hv25_spw=0
parameters dwu0p_hv25_spw=0
parameters dpu0p_hv25_spw=0
parameters dnfactorp_hv25_spw=0
parameters dlnfactorp_hv25_spw=0
parameters dwnfactorp_hv25_spw=0
parameters dpnfactorp_hv25_spw=0
parameters dvsatp_hv25_spw=0
parameters dlvsatp_hv25_spw=0
parameters dwvsatp_hv25_spw=0
parameters dpvsatp_hv25_spw=0
parameters deta0p_hv25_spw=0
parameters dcitp_hv25_spw=0
parameters dlcitp_hv25_spw=0
parameters dwcitp_hv25_spw=0
parameters dpcitp_hv25_spw=0
parameters dvoffp_hv25_spw=0
parameters dlvoffp_hv25_spw=0
parameters dwvoffp_hv25_spw=0
parameters dpvoffp_hv25_spw=0
parameters da0p_hv25_spw=0
parameters dla0p_hv25_spw=0
parameters dwa0p_hv25_spw=0
parameters dpa0p_hv25_spw=0
parameters dagsp_hv25_spw=0
parameters dlagsp_hv25_spw=0
parameters dwagsp_hv25_spw=0
parameters dpagsp_hv25_spw=0
parameters djtsswgdp_hv25_spw=0
parameters djtsswgsp_hv25_spw=0
parameters dkt1p_hv25_spw=0
parameters dlkt1p_hv25_spw=0
parameters dwkt1p_hv25_spw=0
parameters dpkt1p_hv25_spw=0
parameters datp_hv25_spw=0
parameters dlatp_hv25_spw=0
parameters dwatp_hv25_spw=0
parameters dpatp_hv25_spw=0
parameters dagidlp_hv25_spw=0
parameters dlagidlp_hv25_spw=0
parameters dwagidlp_hv25_spw=0
parameters dpagidlp_hv25_spw=0
parameters dbgidlp_hv25_spw=0
parameters dlbgidlp_hv25_spw=0
parameters dwbgidlp_hv25_spw=0
parameters dpbgidlp_hv25_spw=0
parameters dnjtsswgp_hv25_spw=0
parameters cfp_hv25_spw=8.01e-11 + 7.69e-11 * ccoflag_hv25_snw_spw
include "cln40lp_hv_2d5_lk_v1d1_1.scs" section=mos_hv25_snw_spw

endsection tt_hv25_snw_spw

// **************************     LIBRARY OF SNSP CORNER CASE     ***************************

section ss_hv25_snw_spw
include "cln40lp_hv_2d5_lk_v1d1_1.scs" section=setup_hv25_snw_spw
parameters a1n_hv25_snw= - 1 * sigma_factor_hv25_snw_spw
parameters a1p_hv25_spw= - 1 * sigma_factor_hv25_snw_spw
parameters a2n_hv25_snw= - 1 * sigma_factor_hv25_snw_spw
parameters a2p_hv25_spw= - 1 * sigma_factor_hv25_snw_spw
parameters a3n_hv25_snw=1 * sigma_factor_hv25_snw_spw
parameters a3p_hv25_spw=1 * sigma_factor_hv25_snw_spw
parameters a4np_hv25_snw_spw= - 1 * sigma_factor_hv25_snw_spw
parameters toxn_hv25_snw=5.7e-09 - 3e-010 * a4np_hv25_snw_spw
parameters dxln_hv25_snw= - 1e-008 * a2n_hv25_snw
parameters dxwn_hv25_snw= - 1.2e-008 * a3n_hv25_snw
parameters cjdn_hv25_snw=1.37e-4 * (1 - 0.07 * a1n_hv25_snw)
parameters cjswdn_hv25_snw=5.26e-10 * (1 - 0.07 * a1n_hv25_snw)
parameters cjswgdn_hv25_snw=6.43e-10 * (1 - 0.07 * a1n_hv25_snw)
parameters cjsn_hv25_snw=0.001063 * (1 - 0.07 * a1n_hv25_snw)
parameters cjswsn_hv25_snw=1.28e-10 * (1 - 0.07 * a1n_hv25_snw)
parameters cjswgsn_hv25_snw=1.56e-10 * (1 - 0.07 * a1n_hv25_snw)
parameters cgdon_hv25_snw=1e-12 * (1 + 0.07 * a4np_hv25_snw_spw)
parameters cgdln_hv25_snw=2.63e-9 * (1 + 0.07 * a4np_hv25_snw_spw)
parameters ddlcn_hv25_snw=2.36e-07
parameters cgson_hv25_snw=1.06035e-12 * (1 + 0.07 * a4np_hv25_snw_spw)
parameters cgsln_hv25_snw=2.37061e-10 * (1 + 0.07 * a4np_hv25_snw_spw)
parameters dvthn_hv25_snw= - 0.012 * a1n_hv25_snw
parameters dlvthn_hv25_snw= - 1.15e-008 * a1n_hv25_snw
parameters dwvthn_hv25_snw= - 3e-009 * a1n_hv25_snw
parameters dpvthn_hv25_snw= - 6.5e-015 * a1n_hv25_snw
parameters du0n_hv25_snw=0.0011 * a1n_hv25_snw
parameters dlu0n_hv25_snw=3.2e-009 * a1n_hv25_snw
parameters dwu0n_hv25_snw= - 4.5e-010 * a1n_hv25_snw
parameters dpu0n_hv25_snw= - 4e-016 * a1n_hv25_snw
parameters dketan_hv25_snw=0
parameters dlketan_hv25_snw=0
parameters dwketan_hv25_snw=0
parameters dpketan_hv25_snw=0
parameters dnfactorn_hv25_snw=0
parameters dlnfactorn_hv25_snw=0
parameters dwnfactorn_hv25_snw=0
parameters dpnfactorn_hv25_snw=0
parameters dvsatn_hv25_snw= - 5000 * a1n_hv25_snw
parameters dwvsatn_hv25_snw=0
parameters dk2n_hv25_snw=0
parameters dlk2n_hv25_snw=0
parameters dwk2n_hv25_snw=0
parameters dpk2n_hv25_snw=0
parameters deta0n_hv25_snw=0
parameters dweta0n_hv25_snw=0
parameters dagsn_hv25_snw= - 1 * a1n_hv25_snw
parameters dlagsn_hv25_snw=5.7e-007 * a1n_hv25_snw
parameters dwagsn_hv25_snw=5.7e-007 * a1n_hv25_snw
parameters dpagsn_hv25_snw= - 2.6e-013 * a1n_hv25_snw
parameters dvoffn_hv25_snw=0
parameters dlvoffn_hv25_snw=0
parameters dwvoffn_hv25_snw=0
parameters dpvoffn_hv25_snw=0
parameters dcitn_hv25_snw=0
parameters dlcitn_hv25_snw=0
parameters dwcitn_hv25_snw=0
parameters dpcitn_hv25_snw=0
parameters duan_hv25_snw=0
parameters dluan_hv25_snw=0
parameters dwuan_hv25_snw=0
parameters dpuan_hv25_snw=0
parameters dubn_hv25_snw=0
parameters dlubn_hv25_snw=0
parameters dwubn_hv25_snw=0
parameters dpubn_hv25_snw=0
parameters djtsswgdn_hv25_snw=0
parameters djtsswgsn_hv25_snw=0
parameters dkt1n_hv25_snw=0
parameters dlkt1n_hv25_snw=0
parameters dwkt1n_hv25_snw=0
parameters dpkt1n_hv25_snw=0
parameters datn_hv25_snw= + 10000 * a1n_hv25_snw
parameters dlatn_hv25_snw=0
parameters dwatn_hv25_snw=0
parameters dpatn_hv25_snw=0
parameters dagidln_hv25_snw=0
parameters dlagidln_hv25_snw=0
parameters dwagidln_hv25_snw=0
parameters dpagidln_hv25_snw=0
parameters dbgidln_hv25_snw=0
parameters dlbgidln_hv25_snw= - 60 * a1n_hv25_snw
parameters dwbgidln_hv25_snw= - 150 * a1n_hv25_snw
parameters dpbgidln_hv25_snw=0.0001 * a1n_hv25_snw
parameters dnjtsswgn_hv25_snw= - 5.5 * a1n_hv25_snw
parameters ss_flag_hv25_snw_spw=0
parameters ff_flag_hv25_snw_spw=0
parameters sf_flag_hv25_snw_spw=0
parameters fs_flag_hv25_snw_spw=0
parameters cfn_hv25_snw=8.02e-11 * (1 + 0.07 * a4np_hv25_snw_spw) + 6.99e-11 * ccoflag_hv25_snw_spw
parameters toxp_hv25_spw=6.13e-09 - 3e-010 * a4np_hv25_snw_spw
parameters dxlp_hv25_spw= - 1e-008 * a2p_hv25_spw
parameters dxwp_hv25_spw= - 1.2e-008 * a3p_hv25_spw
parameters cjdp_hv25_spw=5.93e-4 * (1 - 0.07 * a1p_hv25_spw)
parameters cjswdp_hv25_spw=3.37e-10 * (1 - 0.07 * a1p_hv25_spw)
parameters cjswgdp_hv25_spw=8e-10 * (1 - 0.07 * a1p_hv25_spw)
parameters cjsp_hv25_spw=1.19000e-03 * (1 - 0.07 * a1p_hv25_spw)
parameters cjswsp_hv25_spw=1.03000e-10 * (1 - 0.07 * a1p_hv25_spw)
parameters cjswgsp_hv25_spw=1.09000e-10 * (1 - 0.07 * a1p_hv25_spw)
parameters cgdop_hv25_spw=1.99e-10 * (1 + 0.07 * a4np_hv25_snw_spw)
parameters cgdlp_hv25_spw=8.25e-10 * (1 + 0.07 * a4np_hv25_snw_spw)
parameters ddlcp_hv25_spw=1.193e-07
parameters cgsop_hv25_spw=6.13160e-13 * (1 + 0.07 * a4np_hv25_snw_spw)
parameters cgslp_hv25_spw=3.34994e-10 * (1 + 0.07 * a4np_hv25_snw_spw)
parameters dvthp_hv25_spw=0.005 * a1p_hv25_spw
parameters dlvthp_hv25_spw=8.5e-009 * a1p_hv25_spw
parameters dwvthp_hv25_spw=1.5e-009 * a1p_hv25_spw
parameters dpvthp_hv25_spw=3e-015 * a1p_hv25_spw
parameters du0p_hv25_spw= - 5e-005 * a1p_hv25_spw
parameters dlu0p_hv25_spw=3e-010 * a1p_hv25_spw
parameters dwu0p_hv25_spw=1.3e-010 * a1p_hv25_spw
parameters dpu0p_hv25_spw=1e-016 * a1p_hv25_spw
parameters dnfactorp_hv25_spw=0
parameters dlnfactorp_hv25_spw=0
parameters dwnfactorp_hv25_spw=0
parameters dpnfactorp_hv25_spw=0
parameters dvsatp_hv25_spw= - 5000 * a1p_hv25_spw
parameters dlvsatp_hv25_spw=0
parameters dwvsatp_hv25_spw=0
parameters dpvsatp_hv25_spw=0
parameters deta0p_hv25_spw=0
parameters dcitp_hv25_spw=0
parameters dlcitp_hv25_spw=0
parameters dwcitp_hv25_spw=0
parameters dpcitp_hv25_spw=0
parameters dvoffp_hv25_spw=0
parameters dlvoffp_hv25_spw=0
parameters dwvoffp_hv25_spw=0
parameters dpvoffp_hv25_spw=0
parameters da0p_hv25_spw=0
parameters dla0p_hv25_spw=0
parameters dwa0p_hv25_spw=0
parameters dpa0p_hv25_spw=0
parameters dagsp_hv25_spw=0
parameters dlagsp_hv25_spw= - 2.2e-007 * a1p_hv25_spw
parameters dwagsp_hv25_spw=0
parameters dpagsp_hv25_spw=1.4e-013 * a1p_hv25_spw
parameters djtsswgdp_hv25_spw=3.8e-009 * a1p_hv25_spw
parameters djtsswgsp_hv25_spw=0
parameters dkt1p_hv25_spw=0
parameters dlkt1p_hv25_spw=0
parameters dwkt1p_hv25_spw=0
parameters dpkt1p_hv25_spw=0
parameters datp_hv25_spw= + 10000 * a1p_hv25_spw
parameters dlatp_hv25_spw=0
parameters dwatp_hv25_spw=0
parameters dpatp_hv25_spw=0
parameters dagidlp_hv25_spw=0
parameters dlagidlp_hv25_spw=0
parameters dwagidlp_hv25_spw=0
parameters dpagidlp_hv25_spw=0
parameters dbgidlp_hv25_spw= - 300000000 * a1p_hv25_spw
parameters dlbgidlp_hv25_spw=0
parameters dwbgidlp_hv25_spw=0
parameters dpbgidlp_hv25_spw=0
parameters dnjtsswgp_hv25_spw= - 4 * a1p_hv25_spw
parameters cfp_hv25_spw=8.01e-11 * (1 + 0.07 * a4np_hv25_snw_spw) + 7.69e-11 * ccoflag_hv25_snw_spw
include "cln40lp_hv_2d5_lk_v1d1_1.scs" section=mos_hv25_snw_spw

endsection ss_hv25_snw_spw

// **************************     LIBRARY OF FNFP CORNER CASE     ***************************

section ff_hv25_snw_spw
include "cln40lp_hv_2d5_lk_v1d1_1.scs" section=setup_hv25_snw_spw
parameters a1n_hv25_snw= - 1 * sigma_factor_hv25_snw_spw
parameters a1p_hv25_spw= - 1 * sigma_factor_hv25_snw_spw
parameters a2n_hv25_snw= - 1 * sigma_factor_hv25_snw_spw
parameters a2p_hv25_spw= - 1 * sigma_factor_hv25_snw_spw
parameters a3n_hv25_snw=1 * sigma_factor_hv25_snw_spw
parameters a3p_hv25_spw=1 * sigma_factor_hv25_snw_spw
parameters a4np_hv25_snw_spw= - 1 * sigma_factor_hv25_snw_spw
parameters toxn_hv25_snw=5.7e-09 + 3.0000e-010 * a4np_hv25_snw_spw
parameters dxln_hv25_snw=1e-008 * a2n_hv25_snw
parameters dxwn_hv25_snw=1.2e-008 * a3n_hv25_snw
parameters cjdn_hv25_snw=1.37e-4 * (1 + 0.070 * a1n_hv25_snw)
parameters cjswdn_hv25_snw=5.26e-10 * (1 + 0.070 * a1n_hv25_snw)
parameters cjswgdn_hv25_snw=6.43e-10 * (1 + 0.070 * a1n_hv25_snw)
parameters cjsn_hv25_snw=0.001063 * (1 + 0.070 * a1n_hv25_snw)
parameters cjswsn_hv25_snw=1.28e-10 * (1 + 0.070 * a1n_hv25_snw)
parameters cjswgsn_hv25_snw=1.56e-10 * (1 + 0.070 * a1n_hv25_snw)
parameters cgdon_hv25_snw=1e-12 * (1 - 0.070 * a4np_hv25_snw_spw)
parameters cgdln_hv25_snw=2.63e-9 * (1 - 0.070 * a4np_hv25_snw_spw)
parameters ddlcn_hv25_snw=2.36e-07
parameters cgson_hv25_snw=1.06035e-12 * (1 - 0.070 * a4np_hv25_snw_spw)
parameters cgsln_hv25_snw=2.37061e-10 * (1 - 0.070 * a4np_hv25_snw_spw)
parameters dvthn_hv25_snw=0.012 * a1n_hv25_snw
parameters dlvthn_hv25_snw=1.15e-008 * a1n_hv25_snw
parameters dwvthn_hv25_snw=3e-009 * a1n_hv25_snw
parameters dpvthn_hv25_snw=6.5e-015 * a1n_hv25_snw
parameters du0n_hv25_snw= - 0.0009 * a1n_hv25_snw
parameters dlu0n_hv25_snw= - 3.6e-009 * a1n_hv25_snw
parameters dwu0n_hv25_snw=5.2e-010 * a1n_hv25_snw
parameters dpu0n_hv25_snw=6.1e-016 * a1n_hv25_snw
parameters dketan_hv25_snw=0
parameters dlketan_hv25_snw= - 2e-8 * a1n_hv25_snw
parameters dwketan_hv25_snw=0
parameters dpketan_hv25_snw=0
parameters dnfactorn_hv25_snw=0.1 * a1n_hv25_snw
parameters dlnfactorn_hv25_snw=0
parameters dwnfactorn_hv25_snw=0
parameters dpnfactorn_hv25_snw=0
parameters dvsatn_hv25_snw=5000 * a1n_hv25_snw
parameters dwvsatn_hv25_snw=0
parameters dk2n_hv25_snw=0
parameters dlk2n_hv25_snw=0
parameters dwk2n_hv25_snw=0
parameters dpk2n_hv25_snw=0
parameters deta0n_hv25_snw=0
parameters dweta0n_hv25_snw=0
parameters dagsn_hv25_snw=1 * a1n_hv25_snw
parameters dlagsn_hv25_snw= - 6e-007 * a1n_hv25_snw
parameters dwagsn_hv25_snw= - 6e-007 * a1n_hv25_snw
parameters dpagsn_hv25_snw=2.73e-013 * a1n_hv25_snw
parameters dvoffn_hv25_snw=0
parameters dlvoffn_hv25_snw=0
parameters dwvoffn_hv25_snw=0
parameters dpvoffn_hv25_snw=0
parameters dcitn_hv25_snw=0
parameters dlcitn_hv25_snw=0
parameters dwcitn_hv25_snw=0
parameters dpcitn_hv25_snw=0.2e-16 * a1n_hv25_snw
parameters duan_hv25_snw=0
parameters dluan_hv25_snw=0
parameters dwuan_hv25_snw=0
parameters dpuan_hv25_snw=0
parameters dubn_hv25_snw=0
parameters dlubn_hv25_snw=0
parameters dwubn_hv25_snw=0
parameters dpubn_hv25_snw=0
parameters djtsswgdn_hv25_snw=0
parameters djtsswgsn_hv25_snw=0
parameters dkt1n_hv25_snw=0
parameters dlkt1n_hv25_snw=0
parameters dwkt1n_hv25_snw=0
parameters dpkt1n_hv25_snw=0
parameters datn_hv25_snw= - 10000 * a1n_hv25_snw
parameters dlatn_hv25_snw=0
parameters dwatn_hv25_snw=0
parameters dpatn_hv25_snw=0
parameters dagidln_hv25_snw=0
parameters dlagidln_hv25_snw=0
parameters dwagidln_hv25_snw=0
parameters dpagidln_hv25_snw=0
parameters dbgidln_hv25_snw=0
parameters dlbgidln_hv25_snw=60 * a1n_hv25_snw
parameters dwbgidln_hv25_snw=200 * a1n_hv25_snw
parameters dpbgidln_hv25_snw= - 0.0003 * a1n_hv25_snw
parameters dnjtsswgn_hv25_snw=1.75 * a1n_hv25_snw
parameters ss_flag_hv25_snw_spw=0
parameters ff_flag_hv25_snw_spw=0
parameters sf_flag_hv25_snw_spw=0
parameters fs_flag_hv25_snw_spw=0
parameters cfn_hv25_snw=8.02e-11 * (1 - 0.070 * a4np_hv25_snw_spw) + 6.99e-11 *
+ ccoflag_hv25_snw_spw
parameters toxp_hv25_spw=6.13e-09 + 3.0000e-010 * a4np_hv25_snw_spw
parameters dxlp_hv25_spw=1e-008 * a2p_hv25_spw
parameters dxwp_hv25_spw=1.2e-008 * a3p_hv25_spw
parameters cjdp_hv25_spw=5.93e-4 * (1 + 0.070 * a1p_hv25_spw)
parameters cjswdp_hv25_spw=3.37e-10 * (1 + 0.070 * a1p_hv25_spw)
parameters cjswgdp_hv25_spw=8e-10 * (1 + 0.070 * a1p_hv25_spw)
parameters cjsp_hv25_spw=1.19000e-03 * (1 + 0.070 * a1p_hv25_spw)
parameters cjswsp_hv25_spw=1.03000e-10 * (1 + 0.070 * a1p_hv25_spw)
parameters cjswgsp_hv25_spw=1.09000e-10 * (1 + 0.070 * a1p_hv25_spw)
parameters cgdop_hv25_spw=1.99e-10 * (1 - 0.070 * a4np_hv25_snw_spw)
parameters cgdlp_hv25_spw=8.25e-10 * (1 - 0.070 * a4np_hv25_snw_spw)
parameters ddlcp_hv25_spw=1.193e-07
parameters cgsop_hv25_spw=6.13160e-13 * (1 - 0.070 * a4np_hv25_snw_spw)
parameters cgslp_hv25_spw=3.34994e-10 * (1 - 0.070 * a4np_hv25_snw_spw)
parameters dvthp_hv25_spw= - 0.005 * a1p_hv25_spw
parameters dlvthp_hv25_spw= - 8.2e-009 * a1p_hv25_spw
parameters dwvthp_hv25_spw= - 1.8e-009 * a1p_hv25_spw
parameters dpvthp_hv25_spw= - 2.8e-015 * a1p_hv25_spw
parameters du0p_hv25_spw=8e-005 * a1p_hv25_spw
parameters dlu0p_hv25_spw= - 2.6e-010 * a1p_hv25_spw
parameters dwu0p_hv25_spw= - 9e-011 * a1p_hv25_spw
parameters dpu0p_hv25_spw= - 9e-017 * a1p_hv25_spw
parameters dnfactorp_hv25_spw=0
parameters dlnfactorp_hv25_spw=0
parameters dwnfactorp_hv25_spw=0
parameters dpnfactorp_hv25_spw=0
parameters dvsatp_hv25_spw=5000 * a1p_hv25_spw
parameters dlvsatp_hv25_spw=0
parameters dwvsatp_hv25_spw=0
parameters dpvsatp_hv25_spw=0
parameters deta0p_hv25_spw=0
parameters dcitp_hv25_spw=0
parameters dlcitp_hv25_spw=0
parameters dwcitp_hv25_spw=0
parameters dpcitp_hv25_spw=0
parameters dvoffp_hv25_spw=0
parameters dlvoffp_hv25_spw=0
parameters dwvoffp_hv25_spw=0
parameters dpvoffp_hv25_spw=0
parameters da0p_hv25_spw=0
parameters dla0p_hv25_spw=0
parameters dwa0p_hv25_spw=0
parameters dpa0p_hv25_spw=0
parameters dagsp_hv25_spw=0
parameters dlagsp_hv25_spw=8e-008 * a1p_hv25_spw
parameters dwagsp_hv25_spw=0
parameters dpagsp_hv25_spw= - 1.2e-013 * a1p_hv25_spw
parameters djtsswgdp_hv25_spw= - 3.8e-009 * a1p_hv25_spw
parameters djtsswgsp_hv25_spw=0
parameters dkt1p_hv25_spw=0
parameters dlkt1p_hv25_spw=0
parameters dwkt1p_hv25_spw=0
parameters dpkt1p_hv25_spw=0
parameters datp_hv25_spw= - 10000 * a1p_hv25_spw
parameters dlatp_hv25_spw=0
parameters dwatp_hv25_spw=0
parameters dpatp_hv25_spw=0
parameters dagidlp_hv25_spw=0
parameters dlagidlp_hv25_spw=0
parameters dwagidlp_hv25_spw=0
parameters dpagidlp_hv25_spw=0
parameters dbgidlp_hv25_spw=350000000 * a1p_hv25_spw
parameters dlbgidlp_hv25_spw=50 * a1p_hv25_spw
parameters dwbgidlp_hv25_spw=0
parameters dpbgidlp_hv25_spw= - 3e-005 * a1p_hv25_spw
parameters dnjtsswgp_hv25_spw=3 * a1p_hv25_spw
parameters cfp_hv25_spw=8.01e-11 * (1 - 0.070 * a4np_hv25_snw_spw) + 7.69e-11 *
+ ccoflag_hv25_snw_spw
include "cln40lp_hv_2d5_lk_v1d1_1.scs" section=mos_hv25_snw_spw

endsection ff_hv25_snw_spw

// **************************     LIBRARY OF SNFP CORNER CASE     ***************************

section sf_hv25_snw_spw
include "cln40lp_hv_2d5_lk_v1d1_1.scs" section=setup_hv25_snw_spw
parameters a1n_hv25_snw=0.8 * sigma_factor_hv25_snw_spw
parameters a1p_hv25_spw= - 0.8 * sigma_factor_hv25_snw_spw
parameters a2n_hv25_snw=0 * sigma_factor_hv25_snw_spw
parameters a2p_hv25_spw=0 * sigma_factor_hv25_snw_spw
parameters a3n_hv25_snw= - 1 * sigma_factor_hv25_snw_spw
parameters a3p_hv25_spw=1 * sigma_factor_hv25_snw_spw
parameters a4np_hv25_snw_spw=0 * sigma_factor_hv25_snw_spw
parameters toxn_hv25_snw=5.7e-09 + 3.0000e-010 * a4np_hv25_snw_spw
parameters dxln_hv25_snw=1e-008 * a2n_hv25_snw
parameters dxwn_hv25_snw=1.2e-008 * a3n_hv25_snw
parameters cjdn_hv25_snw=1.37e-4 * (1 + 0.070 * a1n_hv25_snw)
parameters cjswdn_hv25_snw=5.26e-10 * (1 + 0.070 * a1n_hv25_snw)
parameters cjswgdn_hv25_snw=6.43e-10 * (1 + 0.070 * a1n_hv25_snw)
parameters cjsn_hv25_snw=0.001063 * (1 + 0.070 * a1n_hv25_snw)
parameters cjswsn_hv25_snw=1.28e-10 * (1 + 0.070 * a1n_hv25_snw)
parameters cjswgsn_hv25_snw=1.56e-10 * (1 + 0.070 * a1n_hv25_snw)
parameters cgdon_hv25_snw=1e-12 * (1 - 0.070 * a4np_hv25_snw_spw)
parameters cgdln_hv25_snw=2.63e-9 * (1 - 0.070 * a4np_hv25_snw_spw)
parameters ddlcn_hv25_snw=2.36e-07
parameters cgson_hv25_snw=1.06035e-12 * (1 - 0.070 * a4np_hv25_snw_spw)
parameters cgsln_hv25_snw=2.37061e-10 * (1 - 0.070 * a4np_hv25_snw_spw)
parameters dvthn_hv25_snw=0.032 * a1n_hv25_snw
parameters dlvthn_hv25_snw=1.4e-008 * a1n_hv25_snw
parameters dwvthn_hv25_snw=3e-009 * a1n_hv25_snw
parameters dpvthn_hv25_snw=6.5e-015 * a1n_hv25_snw
parameters du0n_hv25_snw= - 0.0015 * a1n_hv25_snw
parameters dlu0n_hv25_snw= - 3.8e-009 * a1n_hv25_snw
parameters dwu0n_hv25_snw=4.5e-010 * a1n_hv25_snw
parameters dpu0n_hv25_snw=6.1e-016 * a1n_hv25_snw
parameters dketan_hv25_snw=0
parameters dlketan_hv25_snw=0
parameters dwketan_hv25_snw=0
parameters dpketan_hv25_snw=0
parameters dnfactorn_hv25_snw=0
parameters dlnfactorn_hv25_snw=0
parameters dwnfactorn_hv25_snw=0
parameters dpnfactorn_hv25_snw=0
parameters dvsatn_hv25_snw=5000 * a1n_hv25_snw
parameters dwvsatn_hv25_snw=0
parameters dk2n_hv25_snw=0
parameters dlk2n_hv25_snw=0
parameters dwk2n_hv25_snw=0
parameters dpk2n_hv25_snw=0
parameters deta0n_hv25_snw=0
parameters dweta0n_hv25_snw=0
parameters dagsn_hv25_snw=1 * a1n_hv25_snw
parameters dlagsn_hv25_snw= - 5.5e-007 * a1n_hv25_snw
parameters dwagsn_hv25_snw= - 5.7e-007 * a1n_hv25_snw
parameters dpagsn_hv25_snw=2.73e-013 * a1n_hv25_snw
parameters dvoffn_hv25_snw=0
parameters dlvoffn_hv25_snw=0
parameters dwvoffn_hv25_snw=0
parameters dpvoffn_hv25_snw=0
parameters dcitn_hv25_snw=0
parameters dlcitn_hv25_snw=0
parameters dwcitn_hv25_snw=0
parameters dpcitn_hv25_snw=0
parameters duan_hv25_snw=0
parameters dluan_hv25_snw=0
parameters dwuan_hv25_snw=0
parameters dpuan_hv25_snw=0
parameters dubn_hv25_snw=0
parameters dlubn_hv25_snw=0
parameters dwubn_hv25_snw=0
parameters dpubn_hv25_snw=0
parameters djtsswgdn_hv25_snw=0
parameters djtsswgsn_hv25_snw=0
parameters dkt1n_hv25_snw=0
parameters dlkt1n_hv25_snw=0
parameters dwkt1n_hv25_snw=0
parameters dpkt1n_hv25_snw=0
parameters datn_hv25_snw= - 10000 * a1n_hv25_snw
parameters dlatn_hv25_snw=0
parameters dwatn_hv25_snw=0
parameters dpatn_hv25_snw=0
parameters dagidln_hv25_snw=0
parameters dlagidln_hv25_snw=0
parameters dwagidln_hv25_snw=0
parameters dpagidln_hv25_snw=0
parameters dbgidln_hv25_snw=0
parameters dlbgidln_hv25_snw=60 * a1n_hv25_snw
parameters dwbgidln_hv25_snw=150 * a1n_hv25_snw
parameters dpbgidln_hv25_snw= - 1e-4 * a1n_hv25_snw
parameters dnjtsswgn_hv25_snw=1.75 * a1n_hv25_snw
parameters ss_flag_hv25_snw_spw=0
parameters ff_flag_hv25_snw_spw=0
parameters sf_flag_hv25_snw_spw=0
parameters fs_flag_hv25_snw_spw=0
parameters cfn_hv25_snw=8.02e-11 * (1 - 0.070 * a4np_hv25_snw_spw) + 6.99e-11 *
+ ccoflag_hv25_snw_spw
parameters toxp_hv25_spw=6.13e-09 + 3.0000e-010 * a4np_hv25_snw_spw
parameters dxlp_hv25_spw=1e-008 * a2p_hv25_spw
parameters dxwp_hv25_spw=1.2e-008 * a3p_hv25_spw
parameters cjdp_hv25_spw=5.93e-4 * (1 + 0.070 * a1p_hv25_spw)
parameters cjswdp_hv25_spw=3.37e-10 * (1 + 0.070 * a1p_hv25_spw)
parameters cjswgdp_hv25_spw=8e-10 * (1 + 0.070 * a1p_hv25_spw)
parameters cjsp_hv25_spw=1.19000e-03 * (1 + 0.070 * a1p_hv25_spw)
parameters cjswsp_hv25_spw=1.03000e-10 * (1 + 0.070 * a1p_hv25_spw)
parameters cjswgsp_hv25_spw=1.09000e-10 * (1 + 0.070 * a1p_hv25_spw)
parameters cgdop_hv25_spw=1.99e-10 * (1 - 0.070 * a4np_hv25_snw_spw)
parameters cgdlp_hv25_spw=8.25e-10 * (1 - 0.070 * a4np_hv25_snw_spw)
parameters ddlcp_hv25_spw=1.193e-07
parameters cgsop_hv25_spw=6.13160e-13 * (1 - 0.070 * a4np_hv25_snw_spw)
parameters cgslp_hv25_spw=3.34994e-10 * (1 - 0.070 * a4np_hv25_snw_spw)
parameters dvthp_hv25_spw= - 0.035 * a1p_hv25_spw
parameters dlvthp_hv25_spw= - 8.7e-009 * a1p_hv25_spw
parameters dwvthp_hv25_spw= - 1.8e-009 * a1p_hv25_spw
parameters dpvthp_hv25_spw= - 2.8e-015 * a1p_hv25_spw
parameters du0p_hv25_spw= - 2.5e-004 * a1p_hv25_spw
parameters dlu0p_hv25_spw= - 5.8e-010 * a1p_hv25_spw
parameters dwu0p_hv25_spw= - 9e-011 * a1p_hv25_spw
parameters dpu0p_hv25_spw= - 1.5e-016 * a1p_hv25_spw
parameters dnfactorp_hv25_spw=0
parameters dlnfactorp_hv25_spw=0
parameters dwnfactorp_hv25_spw=0
parameters dpnfactorp_hv25_spw=0
parameters dvsatp_hv25_spw=5000 * a1p_hv25_spw
parameters dlvsatp_hv25_spw=0
parameters dwvsatp_hv25_spw=0
parameters dpvsatp_hv25_spw=0
parameters deta0p_hv25_spw=0
parameters dcitp_hv25_spw=0
parameters dlcitp_hv25_spw=0
parameters dwcitp_hv25_spw=0
parameters dpcitp_hv25_spw=0
parameters dvoffp_hv25_spw=0
parameters dlvoffp_hv25_spw=0
parameters dwvoffp_hv25_spw=0
parameters dpvoffp_hv25_spw=0
parameters da0p_hv25_spw=0
parameters dla0p_hv25_spw=0
parameters dwa0p_hv25_spw=0
parameters dpa0p_hv25_spw=0
parameters dagsp_hv25_spw=0
parameters dlagsp_hv25_spw=8e-008 * a1p_hv25_spw
parameters dwagsp_hv25_spw=0
parameters dpagsp_hv25_spw= - 1.2e-013 * a1p_hv25_spw
parameters djtsswgdp_hv25_spw= - 3.8e-009 * a1p_hv25_spw
parameters djtsswgsp_hv25_spw=0
parameters dkt1p_hv25_spw=0
parameters dlkt1p_hv25_spw=0
parameters dwkt1p_hv25_spw=0
parameters dpkt1p_hv25_spw=0
parameters datp_hv25_spw= - 10000 * a1p_hv25_spw
parameters dlatp_hv25_spw=0
parameters dwatp_hv25_spw=0
parameters dpatp_hv25_spw=0
parameters dagidlp_hv25_spw=0
parameters dlagidlp_hv25_spw=0
parameters dwagidlp_hv25_spw=0
parameters dpagidlp_hv25_spw=0
parameters dbgidlp_hv25_spw=350000000 * a1p_hv25_spw
parameters dlbgidlp_hv25_spw=50 * a1p_hv25_spw
parameters dwbgidlp_hv25_spw=0
parameters dpbgidlp_hv25_spw= - 3e-005 * a1p_hv25_spw
parameters dnjtsswgp_hv25_spw=3 * a1p_hv25_spw
parameters cfp_hv25_spw=8.01e-11 * (1 - 0.070 * a4np_hv25_snw_spw) + 7.69e-11 *
+ ccoflag_hv25_snw_spw
include "cln40lp_hv_2d5_lk_v1d1_1.scs" section=mos_hv25_snw_spw

endsection sf_hv25_snw_spw

// **************************     LIBRARY OF FNSP CORNER CASE     ***************************

section fs_hv25_snw_spw
include "cln40lp_hv_2d5_lk_v1d1_1.scs" section=setup_hv25_snw_spw
parameters a1n_hv25_snw= - 0.8 * sigma_factor_hv25_snw_spw
parameters a1p_hv25_spw=0.8 * sigma_factor_hv25_snw_spw
parameters a2n_hv25_snw=0 * sigma_factor_hv25_snw_spw
parameters a2p_hv25_spw=0 * sigma_factor_hv25_snw_spw
parameters a3n_hv25_snw=1 * sigma_factor_hv25_snw_spw
parameters a3p_hv25_spw= - 1 * sigma_factor_hv25_snw_spw
parameters a4np_hv25_snw_spw=0 * sigma_factor_hv25_snw_spw
parameters toxn_hv25_snw=5.7e-09 + 3.0000e-010 * a4np_hv25_snw_spw
parameters dxln_hv25_snw=1e-008 * a2n_hv25_snw
parameters dxwn_hv25_snw=1.2e-008 * a3n_hv25_snw
parameters cjdn_hv25_snw=1.37e-4 * (1 + 0.070 * a1n_hv25_snw)
parameters cjswdn_hv25_snw=5.26e-10 * (1 + 0.070 * a1n_hv25_snw)
parameters cjswgdn_hv25_snw=6.43e-10 * (1 + 0.070 * a1n_hv25_snw)
parameters cjsn_hv25_snw=0.001063 * (1 + 0.070 * a1n_hv25_snw)
parameters cjswsn_hv25_snw=1.28e-10 * (1 + 0.070 * a1n_hv25_snw)
parameters cjswgsn_hv25_snw=1.56e-10 * (1 + 0.070 * a1n_hv25_snw)
parameters cgdon_hv25_snw=1e-12 * (1 - 0.070 * a4np_hv25_snw_spw)
parameters cgdln_hv25_snw=2.63e-9 * (1 - 0.070 * a4np_hv25_snw_spw)
parameters ddlcn_hv25_snw=2.36e-07
parameters cgson_hv25_snw=1.06035e-12 * (1 - 0.070 * a4np_hv25_snw_spw)
parameters cgsln_hv25_snw=2.37061e-10 * (1 - 0.070 * a4np_hv25_snw_spw)
parameters dvthn_hv25_snw=0.032 * a1n_hv25_snw
parameters dlvthn_hv25_snw=1.4e-008 * a1n_hv25_snw
parameters dwvthn_hv25_snw=3e-009 * a1n_hv25_snw
parameters dpvthn_hv25_snw=6.5e-015 * a1n_hv25_snw
parameters du0n_hv25_snw= - 0.0015 * a1n_hv25_snw
parameters dlu0n_hv25_snw= - 3.8e-009 * a1n_hv25_snw
parameters dwu0n_hv25_snw=4.5e-010 * a1n_hv25_snw
parameters dpu0n_hv25_snw=6.1e-016 * a1n_hv25_snw
parameters dketan_hv25_snw=0
parameters dlketan_hv25_snw= - 2e-8 * a1n_hv25_snw
parameters dwketan_hv25_snw=0
parameters dpketan_hv25_snw=0
parameters dnfactorn_hv25_snw=0
parameters dlnfactorn_hv25_snw=0
parameters dwnfactorn_hv25_snw=0
parameters dpnfactorn_hv25_snw=0
parameters dvsatn_hv25_snw=5000 * a1n_hv25_snw
parameters dwvsatn_hv25_snw=0
parameters dk2n_hv25_snw=0
parameters dlk2n_hv25_snw=0
parameters dwk2n_hv25_snw=0
parameters dpk2n_hv25_snw=0
parameters deta0n_hv25_snw=0
parameters dweta0n_hv25_snw=0
parameters dagsn_hv25_snw=1 * a1n_hv25_snw
parameters dlagsn_hv25_snw= - 5.5e-007 * a1n_hv25_snw
parameters dwagsn_hv25_snw= - 5.7e-007 * a1n_hv25_snw
parameters dpagsn_hv25_snw=2.73e-013 * a1n_hv25_snw
parameters dvoffn_hv25_snw=0
parameters dlvoffn_hv25_snw=0
parameters dwvoffn_hv25_snw=0
parameters dpvoffn_hv25_snw=0
parameters dcitn_hv25_snw=0
parameters dlcitn_hv25_snw=0
parameters dwcitn_hv25_snw=0
parameters dpcitn_hv25_snw=0
parameters duan_hv25_snw=0
parameters dluan_hv25_snw=0
parameters dwuan_hv25_snw=0
parameters dpuan_hv25_snw=0
parameters dubn_hv25_snw=0
parameters dlubn_hv25_snw=0
parameters dwubn_hv25_snw=0
parameters dpubn_hv25_snw=0
parameters djtsswgdn_hv25_snw=0
parameters djtsswgsn_hv25_snw=0
parameters dkt1n_hv25_snw=0
parameters dlkt1n_hv25_snw=0
parameters dwkt1n_hv25_snw=0
parameters dpkt1n_hv25_snw=0
parameters datn_hv25_snw= - 10000 * a1n_hv25_snw
parameters dlatn_hv25_snw=0
parameters dwatn_hv25_snw=0
parameters dpatn_hv25_snw=0
parameters dagidln_hv25_snw=0
parameters dlagidln_hv25_snw=0
parameters dwagidln_hv25_snw=0
parameters dpagidln_hv25_snw=0
parameters dbgidln_hv25_snw=0
parameters dlbgidln_hv25_snw=60 * a1n_hv25_snw
parameters dwbgidln_hv25_snw=150 * a1n_hv25_snw
parameters dpbgidln_hv25_snw= - 1e-4 * a1n_hv25_snw
parameters dnjtsswgn_hv25_snw=1.75 * a1n_hv25_snw
parameters ss_flag_hv25_snw_spw=0
parameters ff_flag_hv25_snw_spw=0
parameters sf_flag_hv25_snw_spw=0
parameters fs_flag_hv25_snw_spw=0
parameters cfn_hv25_snw=8.02e-11 * (1 - 0.070 * a4np_hv25_snw_spw) + 6.99e-11 *
+ ccoflag_hv25_snw_spw
parameters toxp_hv25_spw=6.13e-09 + 3.0000e-010 * a4np_hv25_snw_spw
parameters dxlp_hv25_spw=1e-008 * a2p_hv25_spw
parameters dxwp_hv25_spw=1.2e-008 * a3p_hv25_spw
parameters cjdp_hv25_spw=5.93e-4 * (1 + 0.070 * a1p_hv25_spw)
parameters cjswdp_hv25_spw=3.37e-10 * (1 + 0.070 * a1p_hv25_spw)
parameters cjswgdp_hv25_spw=8e-10 * (1 + 0.070 * a1p_hv25_spw)
parameters cjsp_hv25_spw=1.19000e-03 * (1 + 0.070 * a1p_hv25_spw)
parameters cjswsp_hv25_spw=1.03000e-10 * (1 + 0.070 * a1p_hv25_spw)
parameters cjswgsp_hv25_spw=1.09000e-10 * (1 + 0.070 * a1p_hv25_spw)
parameters cgdop_hv25_spw=1.99e-10 * (1 - 0.070 * a4np_hv25_snw_spw)
parameters cgdlp_hv25_spw=8.25e-10 * (1 - 0.070 * a4np_hv25_snw_spw)
parameters ddlcp_hv25_spw=1.193e-07
parameters cgsop_hv25_spw=6.13160e-13 * (1 - 0.070 * a4np_hv25_snw_spw)
parameters cgslp_hv25_spw=3.34994e-10 * (1 - 0.070 * a4np_hv25_snw_spw)
parameters dvthp_hv25_spw= - 0.035 * a1p_hv25_spw
parameters dlvthp_hv25_spw= - 8.7e-009 * a1p_hv25_spw
parameters dwvthp_hv25_spw= - 1.8e-009 * a1p_hv25_spw
parameters dpvthp_hv25_spw= - 2.8e-015 * a1p_hv25_spw
parameters du0p_hv25_spw= - 2.5e-004 * a1p_hv25_spw
parameters dlu0p_hv25_spw= - 5.8e-010 * a1p_hv25_spw
parameters dwu0p_hv25_spw= - 9e-011 * a1p_hv25_spw
parameters dpu0p_hv25_spw= - 1.5e-016 * a1p_hv25_spw
parameters dnfactorp_hv25_spw=0
parameters dlnfactorp_hv25_spw=0
parameters dwnfactorp_hv25_spw=0
parameters dpnfactorp_hv25_spw=0
parameters dvsatp_hv25_spw=5000 * a1p_hv25_spw
parameters dlvsatp_hv25_spw=0
parameters dwvsatp_hv25_spw=0
parameters dpvsatp_hv25_spw=0
parameters deta0p_hv25_spw=0
parameters dcitp_hv25_spw=0
parameters dlcitp_hv25_spw=0
parameters dwcitp_hv25_spw=0
parameters dpcitp_hv25_spw=0
parameters dvoffp_hv25_spw=0
parameters dlvoffp_hv25_spw=0
parameters dwvoffp_hv25_spw=0
parameters dpvoffp_hv25_spw=0
parameters da0p_hv25_spw=0
parameters dla0p_hv25_spw=0
parameters dwa0p_hv25_spw=0
parameters dpa0p_hv25_spw=0
parameters dagsp_hv25_spw=0
parameters dlagsp_hv25_spw=8e-008 * a1p_hv25_spw
parameters dwagsp_hv25_spw=0
parameters dpagsp_hv25_spw= - 1.2e-013 * a1p_hv25_spw
parameters djtsswgdp_hv25_spw= - 3.8e-009 * a1p_hv25_spw
parameters djtsswgsp_hv25_spw=0
parameters dkt1p_hv25_spw=0
parameters dlkt1p_hv25_spw=0
parameters dwkt1p_hv25_spw=0
parameters dpkt1p_hv25_spw=0
parameters datp_hv25_spw= - 10000 * a1p_hv25_spw
parameters dlatp_hv25_spw=0
parameters dwatp_hv25_spw=0
parameters dpatp_hv25_spw=0
parameters dagidlp_hv25_spw=0
parameters dlagidlp_hv25_spw=0
parameters dwagidlp_hv25_spw=0
parameters dpagidlp_hv25_spw=0
parameters dbgidlp_hv25_spw=350000000 * a1p_hv25_spw
parameters dlbgidlp_hv25_spw=50 * a1p_hv25_spw
parameters dwbgidlp_hv25_spw=0
parameters dpbgidlp_hv25_spw= - 3e-005 * a1p_hv25_spw
parameters dnjtsswgp_hv25_spw=3 * a1p_hv25_spw
parameters cfp_hv25_spw=8.01e-11 * (1 - 0.070 * a4np_hv25_snw_spw) + 7.69e-11 *
+ ccoflag_hv25_snw_spw
include "cln40lp_hv_2d5_lk_v1d1_1.scs" section=mos_hv25_snw_spw

endsection fs_hv25_snw_spw

// **************************************************************
//                                                              *
//                      2.5V IO DEVICE MODELS                   *
//                                                              *
// **************************************************************

section mos_hv25_snw_spw
// *********************************************************************************************
//
//                   *
//                                    2.5V NMOS DEVICE MODELS
//                     *
//
//                   *
// *********************************************************************************************

model nch_hv25_snw bsim4  {
     1: type=n
+ lmin=1e-005-dxln_hv25_snw lmax=0.000900001          wmin=2e-005-dxwn_hv25_snw
+ wmax=0.000900001          version=4.5               binunit=2
+ paramchk=1                mobmod=0                  capmod=2
+ igcmod=0                  igbmod=0                  diomod=1
+ rdsmod=1                  rbodymod=0                rgeomod=1
+ rgatemod=1*rgflag_hv25_snw_spw                      permod=1
+ acnqsmod=0                trnqsmod=0                tempmod=0
+ tnom=25                   toxe=toxn_hv25_snw        toxm=5.7e-009
+ dtox=3.1372e-010          epsrox=3.9                wint=0
+ lint=2.23e-007            ll=0                      wl=0
+ lln=1                     wln=1                     lw=0
+ ww=0                      lwn=1                     wwn=1
+ lwl=0                     wwl=0                     llc=0
+ wlc=0                     lwc=0                     wwc=0
+ lwlc=0                    wwlc=0                    xl=2.2e-08+dxln_hv25_snw
+ xw=0+dxwn_hv25_snw        dlc=ddlcn_hv25_snw        dwc=0
+ xpart=1                   toxref=3e-009             dlcig=2.5e-009
+ vth0=0.52485+dvthn_hv25_snw                         k1=0.33827
+ k2=0.1439+dk2n_hv25_snw   k3=-1.82                  k3b=1.0692
+ w0=0                      dvt0=2                    dvt1=0.0055
+ dvt2=0.0087               dvt0w=0                   dvt1w=0
+ dvt2w=0                   dsub=0.22592              minv=-0.4484
+ voffl=-5e-009             dvtp0=2.1516e-007         dvtp1=0.01
+ lpe0=5.3147e-007          lpeb=1e-011               xj=6.7e-008
+ ngate=8.5997e+020         ndep=9e+017               nsd=1e+020
+ phin=0.185                cdsc=0                    cdscb=0
+ cdscd=0                   cit=0.00090025+dcitn_hv25_snw
+ lcit=-8.7991105e-018+dlcitn_hv25_snw                wcit=-8.8032603e-018+dwcitn_hv25_snw
+ pcit=7.9192089e-021+dpcitn_hv25_snw                 voff=-0.13578+dvoffn_hv25_snw
+ nfactor=0.6+dnfactorn_hv25_snw                      eta0=0.012+deta0n_hv25_snw
+ etab=-0.0527251           ud=0                      lud=0
+ wud=0                     pud=0                     u0=0.04+du0n_hv25_snw
+ ua=8.04e-011+duan_hv25_snw                          ub=2.2193e-018+dubn_hv25_snw
+ uc=1.7173e-010            vsat=140000+dvsatn_hv25_snw
+ a0=-0.02                  la0=-1.0998889e-015       wa0=-1.1004073e-015
+ pa0=9.8990111e-019        ags=1+dagsn_hv25_snw      a1=0
+ a2=1                      b0=0                      b1=0
+ keta=-0.04099+dketan_hv25_snw                       dwg=0
+ dwb=0                     pclm=0.01                 pdiblc1=0
+ pdiblc2=5e-005            pdiblcb=0                 drout=0.56
+ pvag=0.45                 delta=0.01                pscbe1=9.264e+008
+ pscbe2=1e-020             fprout=750                pdits=0
+ pditsd=0                  pditsl=0                  rsh=1.750000e+01
+ rsw=100                   rdw=772                   prwg=0
+ prwb=0                    wr=1                      alpha0=6.3669e-008
+ alpha1=1.7728             beta0=28.5                agidl=1e-007+dagidln_hv25_snw
+ bgidl=4.7604593e+009+dbgidln_hv25_snw               cgidl=21.599
+ egidl=0.55661             aigbacc=0.01238           bigbacc=0.006109
+ cigbacc=0.2809            nigbacc=4.05              aigbinv=0.35
+ bigbinv=0.03              cigbinv=0.006             eigbinv=1.1
+ nigbinv=1                 aigc=0.009898             bigc=0.001383
+ cigc=1.515e-005           aigsd=0.0086              bigsd=0.0004353
+ cigsd=3.925e-020          nigc=1                    poxedge=1
+ pigcd=1.672               ntox=1                    xrcrg1=12
+ xrcrg2=1                  cgso=cgson_hv25_snw       cgdo=cgdon_hv25_snw
+ cgbo=0                    cgdl=cgdln_hv25_snw       cgsl=cgsln_hv25_snw
+ clc=1e-007                cle=0.6                   cf=cfn_hv25_snw
+ ckappas=0.6               ckappad=0.6               acde=0.5
+ moin=5.2                  noff=2.3652               voffcv=-0.27608
+ tvoff=0.001               ltvoff=0                  wtvoff=0
+ ptvoff=0                  kt1=-0.30595772+dkt1n_hv25_snw
+ kt1l=0                    kt2=-0.066333             ute=-1.5
+ ua1=2.5042417e-009        ub1=-3.1352295e-018       uc1=2.4720501e-011
+ wuc1=8.181818e-023        prt=0                     at=-150000+datn_hv25_snw
+ jss=1.850000e-07          jsws=3.310000e-13         jswgs=3.310000e-13
+ njs=1.02                  njd=1.02                  ijthsfwd=0.01
+ ijthdfwd=0.01             ijthsrev=0.01             ijthdrev=0.01
+ bvs=9.300000e+00          xjbvs=1                   xjbvd=1
+ jsd=9.604700e-07          jswd=7.784700e-13         jswgd=7.784700e-13
+ bvd=1.410000e+01          jtsswgs=1e-010+djtsswgsn_hv25_snw
+ jtsswgd=1e-008+djtsswgdn_hv25_snw                   njtsswg=5.8+dnjtsswgn_hv25_snw
+ xtsswgs=0.1               xtsswgd=0.36533           tnjtsswg=1
+ vtsswgs=1                 vtsswgd=1                 pbs=7.800000e-01
+ cjs=cjsn_hv25_snw         mjs=2.900000e-01          pbsws=5.200000e-01
+ cjsws=cjswsn_hv25_snw     mjsws=9.300000e-02        pbswgs=5.500000e-01
+ cjswgs=cjswgsn_hv25_snw   mjswgs=2.200000e-01       pbd=6.000000e-01
+ cjd=cjdn_hv25_snw         mjd=3.600000e-01          pbswd=6.500000e-01
+ cjswd=cjswdn_hv25_snw     mjswd=2.800000e-01        pbswgd=7.000000e-01
+ cjswgd=cjswgdn_hv25_snw   mjswgd=3.300000e-01       tpb=2.200000e-03
+ tcj=2.000000e-03          tpbsw=2.000000e-03        tcjsw=1.160000e-03
+ tpbswg=2.500000e-03       tcjswg=1.640000e-03       xtis=3
+ xtid=3                    dmcg=5.800000e-08         dmci=5.800000e-08
+ dmdg=0                    dmcgt=0                   dwj=0
+ xgw=0                     xgl=-1.090000e-08         rshg=1.560000e+01
+ gbmin=1e-012              rbpb=50                   rbpd=50
+ rbps=50                   rbdb=50                   rbsb=50
+ ngcon=1                   pketa=0+dpketan_hv25_snw  wketa=0+dwketan_hv25_snw
+ lketa=0+dlketan_hv25_snw  lvth0=0+dlvthn_hv25_snw   wvth0=0+dwvthn_hv25_snw
+ pvth0=0+dpvthn_hv25_snw   lk2=0+dlk2n_hv25_snw      wk2=0+dwk2n_hv25_snw
+ pk2=0+dpk2n_hv25_snw      lvoff=0+dlvoffn_hv25_snw  wvoff=0+dwvoffn_hv25_snw
+ pvoff=0+dpvoffn_hv25_snw  lu0=0+dlu0n_hv25_snw      wu0=0+dwu0n_hv25_snw
+ pu0=0+dpu0n_hv25_snw      lnfactor=0+dlnfactorn_hv25_snw
+ wnfactor=0+dwnfactorn_hv25_snw                      pnfactor=0+dpnfactorn_hv25_snw
+ lua=0+dluan_hv25_snw      wua=0+dwuan_hv25_snw      pua=0+dpuan_hv25_snw
+ lub=0+dlubn_hv25_snw      wub=0+dwubn_hv25_snw      pub=0+dpubn_hv25_snw
+ lags=0+dlagsn_hv25_snw    wags=0+dwagsn_hv25_snw    pags=0+dpagsn_hv25_snw
+ lagidl=0+dlagidln_hv25_snw                          wagidl=0+dwagidln_hv25_snw
+ pagidl=0+dpagidln_hv25_snw                          lbgidl=0+dlbgidln_hv25_snw
+ wbgidl=0+dwbgidln_hv25_snw                          pbgidl=0+dpbgidln_hv25_snw
+ lkt1=0+dlkt1n_hv25_snw    wkt1=0+dwkt1n_hv25_snw    pkt1=0+dpkt1n_hv25_snw
+ wat=0+dwatn_hv25_snw      lat=0+dlatn_hv25_snw      pat=0+dpatn_hv25_snw
+ weta0=0+dweta0n_hv25_snw  wvsat=0+dwvsatn_hv25_snw  minr=1e-3

     2: type=n
+ lmin=1e-006-dxln_hv25_snw lmax=1e-005-dxln_hv25_snw wmin=2e-005-dxwn_hv25_snw
+ wmax=0.000900001          version=4.5               binunit=2
+ paramchk=1                mobmod=0                  capmod=2
+ igcmod=0                  igbmod=0                  diomod=1
+ rdsmod=1                  rbodymod=0                rgeomod=1
+ rgatemod=1*rgflag_hv25_snw_spw                      permod=1
+ acnqsmod=0                trnqsmod=0                tempmod=0
+ tnom=25                   toxe=toxn_hv25_snw        toxm=5.7e-009
+ dtox=3.1372e-010          epsrox=3.9                wint=0
+ lint=2.23e-007            ll=0                      wl=0
+ lln=1                     wln=1                     lw=0
+ ww=0                      lwn=1                     wwn=1
+ lwl=0                     wwl=0                     llc=0
+ wlc=0                     lwc=0                     wwc=0
+ lwlc=0                    wwlc=0                    xl=2.2e-08+dxln_hv25_snw
+ xw=0+dxwn_hv25_snw        dlc=ddlcn_hv25_snw        dwc=0
+ xpart=1                   toxref=3e-009             dlcig=2.5e-009
+ vth0=0.51279944+dvthn_hv25_snw                      lvth0=1.1539616e-007+dlvthn_hv25_snw
+ wvth0=-1.3090909e-014+dwvthn_hv25_snw               pvth0=1.2535854e-019+dpvthn_hv25_snw
+ k1=0.33827                k2=0.1439+dk2n_hv25_snw   k3=-1.82
+ k3b=1.0692                w0=0                      dvt0=2
+ dvt1=0.0055               dvt2=0.0087               dvt0w=0
+ dvt1w=0                   dvt2w=0                   dsub=0.22592
+ minv=-0.4484              voffl=-5e-009             dvtp0=2.1516e-007
+ dvtp1=0.01                lpe0=5.3147e-007          lpeb=1e-011
+ xj=6.7e-008               ngate=8.5997e+020         ndep=9e+017
+ nsd=1e+020                phin=0.185                cdsc=0
+ cdscb=0                   cdscd=0                   cit=0.00090025+dcitn_hv25_snw
+ wcit=8.181818e-016+dwcitn_hv25_snw                  voff=-0.136468+dvoffn_hv25_snw
+ lvoff=6.588288e-009+dlvoffn_hv25_snw                nfactor=0.6+dnfactorn_hv25_snw
+ eta0=0.012+deta0n_hv25_snw                          etab=-0.0527251
+ ud=0                      lud=0                     wud=0
+ pud=0                     u0=0.03936+du0n_hv25_snw  lu0=6.12864e-009+dlu0n_hv25_snw
+ ua=8.039936e-011+duan_hv25_snw                      lua=6.12864e-021+dluan_hv25_snw
+ ub=2.2184168e-018+dubn_hv25_snw                     lub=8.4575232e-027+dlubn_hv25_snw
+ uc=1.7173e-010            vsat=140000+dvsatn_hv25_snw
+ a0=0.017118079            la0=-3.5544273e-007       wa0=1.0881818e-013
+ pa0=-6.2679272e-020       ags=0.9955776+dagsn_hv25_snw
+ lags=4.2348902e-008+dlagsn_hv25_snw                 a1=0
+ a2=1                      b0=0                      b1=0
+ keta=-0.04099+dketan_hv25_snw                       dwg=0
+ dwb=0                     pclm=0.01                 pdiblc1=0
+ pdiblc2=5e-005            pdiblcb=0                 drout=0.56
+ pvag=0.45                 delta=0.01                pscbe1=9.264e+008
+ pscbe2=1e-020             fprout=750                pdits=0
+ pditsd=0                  pditsl=0                  rsh=1.750000e+01
+ rsw=100                   rdw=772                   prwg=0
+ prwb=0                    wr=1                      alpha0=6.3669e-008
+ alpha1=1.7728             beta0=28.5                agidl=1e-007+dagidln_hv25_snw
+ bgidl=4.7604593e+009+dbgidln_hv25_snw               cgidl=21.599
+ egidl=0.55661             aigbacc=0.01238           bigbacc=0.006109
+ cigbacc=0.2809            nigbacc=4.05              aigbinv=0.35
+ bigbinv=0.03              cigbinv=0.006             eigbinv=1.1
+ nigbinv=1                 aigc=0.009898             bigc=0.001383
+ cigc=1.515e-005           aigsd=0.0086              bigsd=0.0004353
+ cigsd=3.925e-020          nigc=1                    poxedge=1
+ pigcd=1.672               ntox=1                    xrcrg1=12
+ xrcrg2=1                  cgso=cgson_hv25_snw       cgdo=cgdon_hv25_snw
+ cgbo=0                    cgdl=cgdln_hv25_snw       cgsl=cgsln_hv25_snw
+ clc=1e-007                cle=0.6                   cf=cfn_hv25_snw
+ ckappas=0.6               ckappad=0.6               acde=0.5
+ moin=5.2                  noff=2.3652               voffcv=-0.27608
+ tvoff=0.001               ltvoff=0                  wtvoff=0
+ ptvoff=0                  kt1=-0.30595772+dkt1n_hv25_snw
+ kt1l=0                    kt2=-0.066333             ute=-1.5
+ ua1=2.5042417e-009        ub1=-3.1352295e-018       uc1=2.4720501e-011
+ wuc1=8.181818e-023        prt=0                     at=-150000+datn_hv25_snw
+ jss=1.850000e-07          jsws=3.310000e-13         jswgs=3.310000e-13
+ njs=1.02                  njd=1.02                  ijthsfwd=0.01
+ ijthdfwd=0.01             ijthsrev=0.01             ijthdrev=0.01
+ bvs=9.300000e+00          xjbvs=1                   xjbvd=1
+ jsd=9.604700e-07          jswd=7.784700e-13         jswgd=7.784700e-13
+ bvd=1.410000e+01          jtsswgs=1e-010+djtsswgsn_hv25_snw
+ jtsswgd=1e-008+djtsswgdn_hv25_snw                   njtsswg=5.8+dnjtsswgn_hv25_snw
+ xtsswgs=0.1               xtsswgd=0.36533           tnjtsswg=1
+ vtsswgs=1                 vtsswgd=1                 pbs=7.800000e-01
+ cjs=cjsn_hv25_snw         mjs=2.900000e-01          pbsws=5.200000e-01
+ cjsws=cjswsn_hv25_snw     mjsws=9.300000e-02        pbswgs=5.500000e-01
+ cjswgs=cjswgsn_hv25_snw   mjswgs=2.200000e-01       pbd=6.000000e-01
+ cjd=cjdn_hv25_snw         mjd=3.600000e-01          pbswd=6.500000e-01
+ cjswd=cjswdn_hv25_snw     mjswd=2.800000e-01        pbswgd=7.000000e-01
+ cjswgd=cjswgdn_hv25_snw   mjswgd=3.300000e-01       tpb=2.200000e-03
+ tcj=2.000000e-03          tpbsw=2.000000e-03        tcjsw=1.160000e-03
+ tpbswg=2.500000e-03       tcjswg=1.640000e-03       xtis=3
+ xtid=3                    dmcg=5.800000e-08         dmci=5.800000e-08
+ dmdg=0                    dmcgt=0                   dwj=0
+ xgw=0                     xgl=-1.090000e-08         rshg=1.560000e+01
+ gbmin=1e-012              rbpb=50                   rbpd=50
+ rbps=50                   rbdb=50                   rbsb=50
+ ngcon=1                   pketa=0+dpketan_hv25_snw  wketa=0+dwketan_hv25_snw
+ lketa=0+dlketan_hv25_snw  lk2=0+dlk2n_hv25_snw      wk2=0+dwk2n_hv25_snw
+ pk2=0+dpk2n_hv25_snw      lcit=0+dlcitn_hv25_snw    pcit=0+dpcitn_hv25_snw
+ wvoff=0+dwvoffn_hv25_snw  pvoff=0+dpvoffn_hv25_snw  wu0=0+dwu0n_hv25_snw
+ pu0=0+dpu0n_hv25_snw      lnfactor=0+dlnfactorn_hv25_snw
+ wnfactor=0+dwnfactorn_hv25_snw                      pnfactor=0+dpnfactorn_hv25_snw
+ wua=0+dwuan_hv25_snw      pua=0+dpuan_hv25_snw      wub=0+dwubn_hv25_snw
+ pub=0+dpubn_hv25_snw      wags=0+dwagsn_hv25_snw    pags=0+dpagsn_hv25_snw
+ lagidl=0+dlagidln_hv25_snw                          wagidl=0+dwagidln_hv25_snw
+ pagidl=0+dpagidln_hv25_snw                          lbgidl=0+dlbgidln_hv25_snw
+ wbgidl=0+dwbgidln_hv25_snw                          pbgidl=0+dpbgidln_hv25_snw
+ lkt1=0+dlkt1n_hv25_snw    wkt1=0+dwkt1n_hv25_snw    pkt1=0+dpkt1n_hv25_snw
+ wat=0+dwatn_hv25_snw      lat=0+dlatn_hv25_snw      pat=0+dpatn_hv25_snw
+ weta0=0+dweta0n_hv25_snw  wvsat=0+dwvsatn_hv25_snw  minr=1e-3

     3: type=n
+ lmin=7.92e-07             lmax=1e-006-dxln_hv25_snw wmin=2e-005-dxwn_hv25_snw
+ wmax=0.000900001          version=4.5               binunit=2
+ paramchk=1                mobmod=0                  capmod=2
+ igcmod=0                  igbmod=0                  diomod=1
+ rdsmod=1                  rbodymod=0                rgeomod=1
+ rgatemod=1*rgflag_hv25_snw_spw                      permod=1
+ acnqsmod=0                trnqsmod=0                tempmod=0
+ tnom=25                   toxe=toxn_hv25_snw        toxm=5.7e-009
+ dtox=3.1372e-010          epsrox=3.9                wint=0
+ lint=2.23e-007            ll=0                      wl=0
+ lln=1                     wln=1                     lw=0
+ ww=0                      lwn=1                     wwn=1
+ lwl=0                     wwl=0                     llc=0
+ wlc=0                     lwc=0                     wwc=0
+ lwlc=0                    wwlc=0                    xl=2.2e-08+dxln_hv25_snw
+ xw=0+dxwn_hv25_snw        dlc=ddlcn_hv25_snw        dwc=0
+ xpart=1                   toxref=3e-009             dlcig=2.5e-009
+ vth0=0.7565304+dvthn_hv25_snw                       lvth0=-2.499287e-008+dlvthn_hv25_snw
+ wvth0=5.8909087e-013+dwvthn_hv25_snw                pvth0=-2.2149817e-019+dpvthn_hv25_snw
+ k1=0.33827                k2=0.1461184+dk2n_hv25_snw
+ lk2=-1.2777984e-009+dlk2n_hv25_snw                  k3=-1.82
+ k3b=1.0692                w0=0                      dvt0=2
+ dvt1=0.0055               dvt2=0.0087               dvt0w=0
+ dvt1w=0                   dvt2w=0                   dsub=0.22592
+ minv=-0.4484              voffl=-5e-009             dvtp0=2.1516e-007
+ dvtp1=0.01                lpe0=5.3147e-007          lpeb=1e-011
+ xj=6.7e-008               ngate=8.5997e+020         ndep=9e+017
+ nsd=1e+020                phin=0.185                cdsc=0
+ cdscb=0                   cdscd=0                   cit=0.0020287191+dcitn_hv25_snw
+ lcit=-6.4999822e-010+dlcitn_hv25_snw                wcit=1.2027272e-015+dwcitn_hv25_snw
+ pcit=-2.2149817e-022+dpcitn_hv25_snw                voff=-0.1532864+dvoffn_hv25_snw
+ lvoff=1.6275686e-008+dlvoffn_hv25_snw               nfactor=0.6+dnfactorn_hv25_snw
+ eta0=-0.0030399981+deta0n_hv25_snw                  leta0=8.6630389e-009
+ etab=-0.0527251           ud=0                      lud=0
+ wud=0                     pud=0                     u0=0.043419994+du0n_hv25_snw
+ lu0=3.7900833e-009+dlu0n_hv25_snw                   wu0=3.8454546e-014+dwu0n_hv25_snw
+ pu0=-2.2149818e-020+dpu0n_hv25_snw                  ua=-1.2864654e-009+duan_hv25_snw
+ lua=7.8732025e-016+dluan_hv25_snw                   ub=2.8536897e-018+dubn_hv25_snw
+ lub=-3.5745966e-025+dlubn_hv25_snw                  uc=3.6941763e-010
+ luc=-1.1386808e-016       vsat=140000+dvsatn_hv25_snw
+ a0=0.40569824             la0=-5.792649e-007        ags=0.65625275+dagsn_hv25_snw
+ lags=2.3780001e-007+dlagsn_hv25_snw                 a1=0
+ a2=1                      b0=0                      b1=0
+ keta=-0.12065932+dketan_hv25_snw                    lketa=4.5889528e-008+dlketan_hv25_snw
+ wketa=-3.9992726e-013+dwketan_hv25_snw              pketa=2.303581e-019+dpketan_hv25_snw
+ dwg=0                     dwb=0                     pclm=-0.084
+ lpclm=5.4144e-008         pdiblc1=0                 pdiblc2=-0.00098400004
+ lpdiblc2=5.9558402e-010   pdiblcb=0                 drout=0.56
+ pvag=0.45                 delta=0.01                pscbe1=9.264e+008
+ pscbe2=1e-020             fprout=750                pdits=0
+ pditsd=0                  pditsl=0                  rsh=1.750000e+01
+ rsw=100                   rdw=772                   prwg=0
+ prwb=0                    wr=1                      alpha0=6.3669e-008
+ alpha1=1.7728             beta0=28.5                agidl=1e-007+dagidln_hv25_snw
+ bgidl=5.2636588e+009+dbgidln_hv25_snw               lbgidl=-289.8429+dlbgidln_hv25_snw
+ cgidl=21.599              egidl=0.55661             aigbacc=0.01238
+ bigbacc=0.006109          cigbacc=0.2809            nigbacc=4.05
+ aigbinv=0.35              bigbinv=0.03              cigbinv=0.006
+ eigbinv=1.1               nigbinv=1                 aigc=0.009898
+ bigc=0.001383             cigc=1.515e-005           aigsd=0.0086
+ bigsd=0.0004353           cigsd=3.925e-020          nigc=1
+ poxedge=1                 pigcd=1.672               ntox=1
+ xrcrg1=12                 xrcrg2=1                  cgso=cgson_hv25_snw
+ cgdo=cgdon_hv25_snw       cgbo=0                    cgdl=cgdln_hv25_snw
+ cgsl=cgsln_hv25_snw       clc=1e-007                cle=0.6
+ cf=cfn_hv25_snw           ckappas=0.6               ckappad=0.6
+ acde=0.5                  moin=5.2                  noff=2.3652
+ voffcv=-0.27608           tvoff=0.001               ltvoff=0
+ wtvoff=0                  ptvoff=0                  kt1=-0.34255705+dkt1n_hv25_snw
+ lkt1=2.1081216e-008+dlkt1n_hv25_snw                 kt1l=0
+ kt2=-0.066333             ute=-1.5                  ua1=2.8758083e-009
+ lua1=-2.1402235e-016      wua1=3.8454545e-021       pua1=-2.2149817e-027
+ ub1=-3.2533495e-018       lub1=6.8037134e-026       uc1=2.4721443e-011
+ luc1=-5.4242444e-022      wuc1=2.3563636e-022       puc1=-8.8599271e-029
+ prt=0                     at=-150000+datn_hv25_snw  jss=1.850000e-07
+ jsws=3.310000e-13         jswgs=3.310000e-13        njs=1.02
+ njd=1.02                  ijthsfwd=0.01             ijthdfwd=0.01
+ ijthsrev=0.01             ijthdrev=0.01             bvs=9.300000e+00
+ xjbvs=1                   xjbvd=1                   jsd=9.604700e-07
+ jswd=7.784700e-13         jswgd=7.784700e-13        bvd=1.410000e+01
+ jtsswgs=1e-010+djtsswgsn_hv25_snw                   jtsswgd=1e-008+djtsswgdn_hv25_snw
+ njtsswg=5.8+dnjtsswgn_hv25_snw                      xtsswgs=0.1
+ xtsswgd=0.36533           tnjtsswg=1                vtsswgs=1
+ vtsswgd=1                 pbs=7.800000e-01          cjs=cjsn_hv25_snw
+ mjs=2.900000e-01          pbsws=5.200000e-01        cjsws=cjswsn_hv25_snw
+ mjsws=9.300000e-02        pbswgs=5.500000e-01       cjswgs=cjswgsn_hv25_snw
+ mjswgs=2.200000e-01       pbd=6.000000e-01          cjd=cjdn_hv25_snw
+ mjd=3.600000e-01          pbswd=6.500000e-01        cjswd=cjswdn_hv25_snw
+ mjswd=2.800000e-01        pbswgd=7.000000e-01       cjswgd=cjswgdn_hv25_snw
+ mjswgd=3.300000e-01       tpb=2.200000e-03          tcj=2.000000e-03
+ tpbsw=2.000000e-03        tcjsw=1.160000e-03        tpbswg=2.500000e-03
+ tcjswg=1.640000e-03       xtis=3                    xtid=3
+ dmcg=5.800000e-08         dmci=5.800000e-08         dmdg=0
+ dmcgt=0                   dwj=0                     xgw=0
+ xgl=-1.090000e-08         rshg=1.560000e+01         gbmin=1e-012
+ rbpb=50                   rbpd=50                   rbps=50
+ rbdb=50                   rbsb=50                   ngcon=1
+ wk2=0+dwk2n_hv25_snw      pk2=0+dpk2n_hv25_snw      wvoff=0+dwvoffn_hv25_snw
+ pvoff=0+dpvoffn_hv25_snw  lnfactor=0+dlnfactorn_hv25_snw
+ wnfactor=0+dwnfactorn_hv25_snw                      pnfactor=0+dpnfactorn_hv25_snw
+ wua=0+dwuan_hv25_snw      pua=0+dpuan_hv25_snw      wub=0+dwubn_hv25_snw
+ pub=0+dpubn_hv25_snw      wags=0+dwagsn_hv25_snw    pags=0+dpagsn_hv25_snw
+ lagidl=0+dlagidln_hv25_snw                          wagidl=0+dwagidln_hv25_snw
+ pagidl=0+dpagidln_hv25_snw                          wbgidl=0+dwbgidln_hv25_snw
+ pbgidl=0+dpbgidln_hv25_snw                          wkt1=0+dwkt1n_hv25_snw
+ pkt1=0+dpkt1n_hv25_snw    wat=0+dwatn_hv25_snw      lat=0+dlatn_hv25_snw
+ pat=0+dpatn_hv25_snw      weta0=0+dweta0n_hv25_snw  wvsat=0+dwvsatn_hv25_snw
+ minr=1e-3

     4: type=n
+ lmin=1e-005-dxln_hv25_snw lmax=0.000900001          wmin=1e-005-dxwn_hv25_snw
+ wmax=2e-005-dxwn_hv25_snw version=4.5               binunit=2
+ paramchk=1                mobmod=0                  capmod=2
+ igcmod=0                  igbmod=0                  diomod=1
+ rdsmod=1                  rbodymod=0                rgeomod=1
+ rgatemod=1*rgflag_hv25_snw_spw                      permod=1
+ acnqsmod=0                trnqsmod=0                tempmod=0
+ tnom=25                   toxe=toxn_hv25_snw        toxm=5.7e-009
+ dtox=3.1372e-010          epsrox=3.9                wint=0
+ lint=2.23e-007            ll=0                      wl=0
+ lln=1                     wln=1                     lw=0
+ ww=0                      lwn=1                     wwn=1
+ lwl=0                     wwl=0                     llc=0
+ wlc=0                     lwc=0                     wwc=0
+ lwlc=0                    wwlc=0                    xl=2.2e-08+dxln_hv25_snw
+ xw=0+dxwn_hv25_snw        dlc=ddlcn_hv25_snw        dwc=0
+ xpart=1                   toxref=3e-009             dlcig=2.5e-009
+ vth0=0.5145+dvthn_hv25_snw                          wvth0=2.07e-007+dwvthn_hv25_snw
+ k1=0.33827                k2=0.1439+dk2n_hv25_snw   k3=-1.82
+ k3b=1.0692                w0=0                      dvt0=2
+ dvt1=0.0055               dvt2=0.0087               dvt0w=0
+ dvt1w=0                   dvt2w=0                   dsub=0.22592
+ minv=-0.4484              voffl=-5e-009             dvtp0=2.1516e-007
+ dvtp1=0.01                lpe0=5.3147e-007          lpeb=1e-011
+ xj=6.7e-008               ngate=8.5997e+020         ndep=9e+017
+ nsd=1e+020                phin=0.185                cdsc=0
+ cdscb=0                   cdscd=0                   cit=0.00100042+dcitn_hv25_snw
+ lcit=7.7432267e-016+dlcitn_hv25_snw                 wcit=-2.0034e-009+dwcitn_hv25_snw
+ pcit=-7.7432267e-021+dpcitn_hv25_snw                voff=-0.14253+dvoffn_hv25_snw
+ wvoff=1.35e-007+dwvoffn_hv25_snw                    nfactor=0.6+dnfactorn_hv25_snw
+ eta0=0.012+deta0n_hv25_snw                          etab=-0.0527251
+ ud=0                      lud=0                     wud=0
+ pud=0                     u0=0.04+du0n_hv25_snw     ua=8.04e-011+duan_hv25_snw
+ lua=-1.9358067e-023+dluan_hv25_snw                  wua=-4.3038134e-025+dwuan_hv25_snw
+ pua=3.8716133e-028+dpuan_hv25_snw                   ub=2.1895e-018+dubn_hv25_snw
+ wub=5.96e-025+dwubn_hv25_snw                        uc=1.7173e-010
+ vsat=140000+dvsatn_hv25_snw                         a0=-0.0038400001
+ la0=1.2582743e-013        wa0=-3.232e-007           pa0=-1.5486453e-018
+ ags=0.9309+dagsn_hv25_snw wags=1.382e-006+dwagsn_hv25_snw
+ a1=0                      a2=1                      b0=0
+ b1=0                      keta=-0.04099+dketan_hv25_snw
+ dwg=0                     dwb=0                     pclm=0.01
+ pdiblc1=0                 pdiblc2=5.0041e-005       wpdiblc2=-8.2e-013
+ pdiblcb=0                 drout=0.56                pvag=0.45
+ delta=0.01                pscbe1=9.264e+008         pscbe2=1e-020
+ fprout=750                pdits=0                   pditsd=0
+ pditsl=0                  rsh=1.750000e+01          rsw=100
+ rdw=772                   prwg=0                    prwb=0
+ wr=1                      alpha0=6.3669e-008        alpha1=1.7728
+ beta0=28.5                agidl=1e-007+dagidln_hv25_snw
+ bgidl=5.025795e+009+dbgidln_hv25_snw                wbgidl=-5306.714+dwbgidln_hv25_snw
+ cgidl=21.599              egidl=0.55661             aigbacc=0.01238
+ bigbacc=0.006109          cigbacc=0.2809            nigbacc=4.05
+ aigbinv=0.35              bigbinv=0.03              cigbinv=0.006
+ eigbinv=1.1               nigbinv=1                 aigc=0.009898
+ bigc=0.001383             cigc=1.515e-005           aigsd=0.0086
+ bigsd=0.0004353           cigsd=3.925e-020          nigc=1
+ poxedge=1                 pigcd=1.672               ntox=1
+ xrcrg1=12                 xrcrg2=1                  cgso=cgson_hv25_snw
+ cgdo=cgdon_hv25_snw       cgbo=0                    cgdl=cgdln_hv25_snw
+ cgsl=cgsln_hv25_snw       clc=1e-007                cle=0.6
+ cf=cfn_hv25_snw           ckappas=0.6               ckappad=0.6
+ acde=0.5                  moin=5.2                  noff=2.3652
+ voffcv=-0.27608           tvoff=0.001               ltvoff=0
+ wtvoff=0                  ptvoff=0                  kt1=-0.31151544+dkt1n_hv25_snw
+ wkt1=1.111544e-007+dwkt1n_hv25_snw                  kt1l=0
+ kt2=-0.066333             ute=-1.5                  ua1=2.7696211e-009
+ wua1=-5.307588e-015       ub1=-3.135359e-018        wub1=2.59e-027
+ uc1=1.2899513e-010        wuc1=-2.0854925e-015      prt=0
+ at=-150000+datn_hv25_snw  jss=1.850000e-07          jsws=3.310000e-13
+ jswgs=3.310000e-13        njs=1.02                  njd=1.02
+ ijthsfwd=0.01             ijthdfwd=0.01             ijthsrev=0.01
+ ijthdrev=0.01             bvs=9.300000e+00          xjbvs=1
+ xjbvd=1                   jsd=9.604700e-07          jswd=7.784700e-13
+ jswgd=7.784700e-13        bvd=1.410000e+01          jtsswgs=1e-010+djtsswgsn_hv25_snw
+ jtsswgd=1e-008+djtsswgdn_hv25_snw                   njtsswg=5.8+dnjtsswgn_hv25_snw
+ xtsswgs=0.1               xtsswgd=0.36533           tnjtsswg=1
+ vtsswgs=1                 vtsswgd=1                 pbs=7.800000e-01
+ cjs=cjsn_hv25_snw         mjs=2.900000e-01          pbsws=5.200000e-01
+ cjsws=cjswsn_hv25_snw     mjsws=9.300000e-02        pbswgs=5.500000e-01
+ cjswgs=cjswgsn_hv25_snw   mjswgs=2.200000e-01       pbd=6.000000e-01
+ cjd=cjdn_hv25_snw         mjd=3.600000e-01          pbswd=6.500000e-01
+ cjswd=cjswdn_hv25_snw     mjswd=2.800000e-01        pbswgd=7.000000e-01
+ cjswgd=cjswgdn_hv25_snw   mjswgd=3.300000e-01       tpb=2.200000e-03
+ tcj=2.000000e-03          tpbsw=2.000000e-03        tcjsw=1.160000e-03
+ tpbswg=2.500000e-03       tcjswg=1.640000e-03       xtis=3
+ xtid=3                    dmcg=5.800000e-08         dmci=5.800000e-08
+ dmdg=0                    dmcgt=0                   dwj=0
+ xgw=0                     xgl=-1.090000e-08         rshg=1.560000e+01
+ gbmin=1e-012              rbpb=50                   rbpd=50
+ rbps=50                   rbdb=50                   rbsb=50
+ ngcon=1                   pketa=0+dpketan_hv25_snw  wketa=0+dwketan_hv25_snw
+ lketa=0+dlketan_hv25_snw  lvth0=0+dlvthn_hv25_snw   pvth0=0+dpvthn_hv25_snw
+ lk2=0+dlk2n_hv25_snw      wk2=0+dwk2n_hv25_snw      pk2=0+dpk2n_hv25_snw
+ lvoff=0+dlvoffn_hv25_snw  pvoff=0+dpvoffn_hv25_snw  lu0=0+dlu0n_hv25_snw
+ wu0=0+dwu0n_hv25_snw      pu0=0+dpu0n_hv25_snw      lnfactor=0+dlnfactorn_hv25_snw
+ wnfactor=0+dwnfactorn_hv25_snw                      pnfactor=0+dpnfactorn_hv25_snw
+ lub=0+dlubn_hv25_snw      pub=0+dpubn_hv25_snw      lags=0+dlagsn_hv25_snw
+ pags=0+dpagsn_hv25_snw    lagidl=0+dlagidln_hv25_snw
+ wagidl=0+dwagidln_hv25_snw                          pagidl=0+dpagidln_hv25_snw
+ lbgidl=0+dlbgidln_hv25_snw                          pbgidl=0+dpbgidln_hv25_snw
+ lkt1=0+dlkt1n_hv25_snw    pkt1=0+dpkt1n_hv25_snw    wat=0+dwatn_hv25_snw
+ lat=0+dlatn_hv25_snw      pat=0+dpatn_hv25_snw      weta0=0+dweta0n_hv25_snw
+ wvsat=0+dwvsatn_hv25_snw  minr=1e-3

     5: type=n
+ lmin=1e-006-dxln_hv25_snw lmax=1e-005-dxln_hv25_snw wmin=1e-005-dxwn_hv25_snw
+ wmax=2e-005-dxwn_hv25_snw version=4.5               binunit=2
+ paramchk=1                mobmod=0                  capmod=2
+ igcmod=0                  igbmod=0                  diomod=1
+ rdsmod=1                  rbodymod=0                rgeomod=1
+ rgatemod=1*rgflag_hv25_snw_spw                      permod=1
+ acnqsmod=0                trnqsmod=0                tempmod=0
+ tnom=25                   toxe=toxn_hv25_snw        toxm=5.7e-009
+ dtox=3.1372e-010          epsrox=3.9                wint=0
+ lint=2.23e-007            ll=0                      wl=0
+ lln=1                     wln=1                     lw=0
+ ww=0                      lwn=1                     wwn=1
+ lwl=0                     wwl=0                     llc=0
+ wlc=0                     lwc=0                     wwc=0
+ lwlc=0                    wwlc=0                    xl=2.2e-08+dxln_hv25_snw
+ xw=0+dxwn_hv25_snw        dlc=ddlcn_hv25_snw        dwc=0
+ xpart=1                   toxref=3e-009             dlcig=2.5e-009
+ vth0=0.50178697+dvthn_hv25_snw                      lvth0=1.2174001e-007+dlvthn_hv25_snw
+ wvth0=2.2024946e-007+dwvthn_hv25_snw                pvth0=-1.2687682e-013+dpvthn_hv25_snw
+ k1=0.33827                k2=0.14390008+dk2n_hv25_snw
+ lk2=-7.4769408e-013+dlk2n_hv25_snw                  wk2=-1.5616e-012+dwk2n_hv25_snw
+ pk2=1.4953882e-017+dpk2n_hv25_snw                   k3=-1.82
+ k3b=1.0692                w0=0                      dvt0=2
+ dvt1=0.0055               dvt2=0.0087               dvt0w=0
+ dvt1w=0                   dvt2w=0                   dsub=0.22592
+ minv=-0.4484              voffl=-5e-009             dvtp0=2.1516e-007
+ dvtp1=0.01                lpe0=5.3147e-007          lpeb=1e-011
+ xj=6.7e-008               ngate=8.5997e+020         ndep=9e+017
+ nsd=1e+020                phin=0.185                cdsc=0
+ cdscb=0                   cdscd=0                   cit=0.0010004203+dcitn_hv25_snw
+ lcit=-1.6057037e-015+dlcitn_hv25_snw                wcit=-2.0034041e-009+dwcitn_hv25_snw
+ pcit=3.2114074e-020+dpcitn_hv25_snw                 voff=-0.14365029+dvoffn_hv25_snw
+ lvoff=1.0727859e-008+dlvoffn_hv25_snw               wvoff=1.4364572e-007+dwvoffn_hv25_snw
+ pvoff=-8.279143e-014+dpvoffn_hv25_snw               nfactor=0.6+dnfactorn_hv25_snw
+ eta0=0.012+deta0n_hv25_snw                          leta0=-6.12864e-016
+ weta0=-1.2799999e-015+dweta0n_hv25_snw              peta0=1.225728e-020
+ etab=-0.0527251           ud=0                      lud=0
+ wud=0                     pud=0                     u0=0.03936+du0n_hv25_snw
+ lu0=6.1286394e-009+dlu0n_hv25_snw                   wu0=-1.2799999e-015+dwu0n_hv25_snw
+ pu0=1.225728e-020+dpu0n_hv25_snw                    ua=8.0399361e-011+duan_hv25_snw
+ lua=6.0949325e-021+dluan_hv25_snw                   wua=-3.04e-023+dwuan_hv25_snw
+ pua=6.741504e-028+dpuan_hv25_snw                    ub=2.1839089e-018+dubn_hv25_snw
+ lub=5.3540534e-026+dlubn_hv25_snw                   wub=6.9015834e-025+dwubn_hv25_snw
+ pub=-9.0166023e-031+dpubn_hv25_snw                  uc=1.7172993e-010
+ luc=6.9866496e-022        wuc=1.4592e-021           puc=-1.3973299e-026
+ vsat=140000+dvsatn_hv25_snw                         a0=0.034312509
+ la0=-3.653483e-007        wa0=-3.4388849e-007       pa0=1.9811145e-013
+ ags=0.92205829+dagsn_hv25_snw                       lags=8.4668203e-008+dlagsn_hv25_snw
+ wags=1.4703862e-006+dwagsn_hv25_snw                 pags=-8.4638602e-013+dpagsn_hv25_snw
+ a1=0                      a2=1                      b0=0
+ b1=0                      keta=-0.040990031+dketan_hv25_snw
+ lketa=2.9417472e-013+dlketan_hv25_snw               wketa=6.144e-013+dwketan_hv25_snw
+ pketa=-5.8834944e-018+dpketan_hv25_snw              dwg=0
+ dwb=0                     pclm=0.01                 pdiblc1=0
+ pdiblc2=5.0040981e-005    lpdiblc2=1.8447206e-016   wpdiblc2=-8.1961472e-013
+ ppdiblc2=-3.6894413e-021  pdiblcb=0                 drout=0.56
+ pvag=0.45                 delta=0.01                pscbe1=9.264e+008
+ pscbe2=1e-020             fprout=750                pdits=0
+ pditsd=0                  pditsl=0                  rsh=1.750000e+01
+ rsw=100                   rdw=772                   prwg=0
+ prwb=0                    wr=1                      alpha0=6.3669e-008
+ alpha1=1.7728             beta0=28.5                agidl=1e-007+dagidln_hv25_snw
+ bgidl=5.025795e+009+dbgidln_hv25_snw                wbgidl=-5306.714+dwbgidln_hv25_snw
+ cgidl=21.599              egidl=0.55661             aigbacc=0.01238
+ bigbacc=0.006109          cigbacc=0.2809            nigbacc=4.05
+ aigbinv=0.35              bigbinv=0.03              cigbinv=0.006
+ eigbinv=1.1               nigbinv=1                 aigc=0.009898
+ bigc=0.001383             cigc=1.515e-005           aigsd=0.0086
+ bigsd=0.0004353           cigsd=3.925e-020          nigc=1
+ poxedge=1                 pigcd=1.672               ntox=1
+ xrcrg1=12                 xrcrg2=1                  cgso=cgson_hv25_snw
+ cgdo=cgdon_hv25_snw       cgbo=0                    cgdl=cgdln_hv25_snw
+ cgsl=cgsln_hv25_snw       clc=1e-007                cle=0.6
+ cf=cfn_hv25_snw           ckappas=0.6               ckappad=0.6
+ acde=0.5                  moin=5.2                  noff=2.3652
+ voffcv=-0.27608           tvoff=0.001               ltvoff=0
+ wtvoff=0                  ptvoff=0                  kt1=-0.31151544+dkt1n_hv25_snw
+ wkt1=1.111544e-007+dwkt1n_hv25_snw                  kt1l=0
+ kt2=-0.066333             ute=-1.5                  ua1=2.7696211e-009
+ wua1=-5.307588e-015       ub1=-3.135359e-018        wub1=2.59e-027
+ uc1=1.2899513e-010        wuc1=-2.0854925e-015      prt=0
+ at=-150000+datn_hv25_snw  jss=1.850000e-07          jsws=3.310000e-13
+ jswgs=3.310000e-13        njs=1.02                  njd=1.02
+ ijthsfwd=0.01             ijthdfwd=0.01             ijthsrev=0.01
+ ijthdrev=0.01             bvs=9.300000e+00          xjbvs=1
+ xjbvd=1                   jsd=9.604700e-07          jswd=7.784700e-13
+ jswgd=7.784700e-13        bvd=1.410000e+01          jtsswgs=1e-010+djtsswgsn_hv25_snw
+ jtsswgd=1e-008+djtsswgdn_hv25_snw                   njtsswg=5.8+dnjtsswgn_hv25_snw
+ xtsswgs=0.1               xtsswgd=0.36533           tnjtsswg=1
+ vtsswgs=1                 vtsswgd=1                 pbs=7.800000e-01
+ cjs=cjsn_hv25_snw         mjs=2.900000e-01          pbsws=5.200000e-01
+ cjsws=cjswsn_hv25_snw     mjsws=9.300000e-02        pbswgs=5.500000e-01
+ cjswgs=cjswgsn_hv25_snw   mjswgs=2.200000e-01       pbd=6.000000e-01
+ cjd=cjdn_hv25_snw         mjd=3.600000e-01          pbswd=6.500000e-01
+ cjswd=cjswdn_hv25_snw     mjswd=2.800000e-01        pbswgd=7.000000e-01
+ cjswgd=cjswgdn_hv25_snw   mjswgd=3.300000e-01       tpb=2.200000e-03
+ tcj=2.000000e-03          tpbsw=2.000000e-03        tcjsw=1.160000e-03
+ tpbswg=2.500000e-03       tcjswg=1.640000e-03       xtis=3
+ xtid=3                    dmcg=5.800000e-08         dmci=5.800000e-08
+ dmdg=0                    dmcgt=0                   dwj=0
+ xgw=0                     xgl=-1.090000e-08         rshg=1.560000e+01
+ gbmin=1e-012              rbpb=50                   rbpd=50
+ rbps=50                   rbdb=50                   rbsb=50
+ ngcon=1                   lnfactor=0+dlnfactorn_hv25_snw
+ wnfactor=0+dwnfactorn_hv25_snw                      pnfactor=0+dpnfactorn_hv25_snw
+ lagidl=0+dlagidln_hv25_snw                          wagidl=0+dwagidln_hv25_snw
+ pagidl=0+dpagidln_hv25_snw                          lbgidl=0+dlbgidln_hv25_snw
+ pbgidl=0+dpbgidln_hv25_snw                          lkt1=0+dlkt1n_hv25_snw
+ pkt1=0+dpkt1n_hv25_snw    wat=0+dwatn_hv25_snw      lat=0+dlatn_hv25_snw
+ pat=0+dpatn_hv25_snw      wvsat=0+dwvsatn_hv25_snw  minr=1e-3

     6: type=n
+ lmin=7.92e-07             lmax=1e-006-dxln_hv25_snw wmin=1e-005-dxwn_hv25_snw
+ wmax=2e-005-dxwn_hv25_snw version=4.5               binunit=2
+ paramchk=1                mobmod=0                  capmod=2
+ igcmod=0                  igbmod=0                  diomod=1
+ rdsmod=1                  rbodymod=0                rgeomod=1
+ rgatemod=1*rgflag_hv25_snw_spw                      permod=1
+ acnqsmod=0                trnqsmod=0                tempmod=0
+ tnom=25                   toxe=toxn_hv25_snw        toxm=5.7e-009
+ dtox=3.1372e-010          epsrox=3.9                wint=0
+ lint=2.23e-007            ll=0                      wl=0
+ lln=1                     wln=1                     lw=0
+ ww=0                      lwn=1                     wwn=1
+ lwl=0                     wwl=0                     llc=0
+ wlc=0                     lwc=0                     wwc=0
+ lwlc=0                    wwlc=0                    xl=2.2e-08+dxln_hv25_snw
+ xw=0+dxwn_hv25_snw        dlc=ddlcn_hv25_snw        dwc=0
+ xpart=1                   toxref=3e-009             dlcig=2.5e-009
+ vth0=0.75653371+dvthn_hv25_snw                      lvth0=-2.4994116e-008+dlvthn_hv25_snw
+ wvth0=-6.5664e-011+dwvthn_hv25_snw                  pvth0=2.4689664e-017+dpvthn_hv25_snw
+ k1=0.33827                k2=0.14611489+dk2n_hv25_snw
+ lk2=-1.2764773e-009+dlk2n_hv25_snw                  wk2=7.0272e-011+dwk2n_hv25_snw
+ pk2=-2.6422272e-017+dpk2n_hv25_snw                  k3=-1.82
+ k3b=1.0692                w0=0                      dvt0=2
+ dvt1=0.0055               dvt2=0.0087               dvt0w=0
+ dvt1w=0                   dvt2w=0                   dsub=0.22592
+ minv=-0.4484              voffl=-5e-009             dvtp0=2.1516e-007
+ dvtp1=0.01                lpe0=5.3147e-007          lpeb=1e-011
+ xj=6.7e-008               ngate=8.5997e+020         ndep=9e+017
+ nsd=1e+020                phin=0.185                cdsc=0
+ cdscb=0                   cdscd=0                   cit=0.0021292004+dcitn_hv25_snw
+ lcit=-6.50179e-010+dlcitn_hv25_snw                  wcit=-2.009625e-009+dwcitn_hv25_snw
+ pcit=3.6153032e-018+dpcitn_hv25_snw                 voff=-0.15327353+dvoffn_hv25_snw
+ lvoff=1.6270846e-008+dlvoffn_hv25_snw               wvoff=-2.57472e-010+dwvoffn_hv25_snw
+ pvoff=9.6809472e-017+dpvoffn_hv25_snw               nfactor=0.6+dnfactorn_hv25_snw
+ eta0=-0.0030399991+deta0n_hv25_snw                  leta0=8.6630389e-009
+ weta0=2e-014+dweta0n_hv25_snw                       peta0=2.0341872e-028
+ etab=-0.0527251           ud=0                      lud=0
+ wud=0                     pud=0                     u0=0.04247999+du0n_hv25_snw
+ lu0=4.3315254e-009+dlu0n_hv25_snw                   wu0=1.8800133e-008+dwu0n_hv25_snw
+ pu0=-1.0828865e-014+dpu0n_hv25_snw                  ua=-1.8524609e-009+duan_hv25_snw
+ lua=1.1133336e-015+dluan_hv25_snw                   wua=1.1319909e-014+dwuan_hv25_snw
+ pua=-6.5202669e-021+dpuan_hv25_snw                  ub=3.3568516e-018+dubn_hv25_snw
+ lub=-6.2207449e-025+dlubn_hv25_snw                  wub=-1.0063239e-023+dwubn_hv25_snw
+ pub=5.2922966e-030+dpubn_hv25_snw                   uc=3.694209e-010
+ luc=-1.138693e-016        wuc=-6.5288e-020          puc=2.4473088e-026
+ vsat=140000+dvsatn_hv25_snw                         a0=0.38162613
+ la0=-5.6540095e-007       wa0=4.8144216e-007        pa0=-2.77279e-013
+ ags=0.7922264+dagsn_hv25_snw                        lags=1.5945137e-007+dlagsn_hv25_snw
+ wags=-2.719473e-006+dwagsn_hv25_snw                 pags=1.5669728e-012+dpagsn_hv25_snw
+ a1=0                      a2=1                      b0=0
+ b1=0                      keta=-0.12065798+dketan_hv25_snw
+ lketa=4.5889033e-008+dlketan_hv25_snw               wketa=-2.71592e-011+dwketan_hv25_snw
+ pketa=1.0114099e-017+dpketan_hv25_snw               dwg=0
+ dwb=0                     pclm=-0.084               lpclm=5.4144e-008
+ pdiblc1=0                 pdiblc2=-0.00098388113    lpdiblc2=5.9553932e-010
+ wpdiblc2=-2.3781856e-012  ppdiblc2=8.9404739e-019   pdiblcb=0
+ drout=0.56                pvag=0.45                 delta=0.01
+ pscbe1=9.264e+008         pscbe2=1e-020             fprout=750
+ pdits=0                   pditsd=0                  pditsl=0
+ rsh=1.750000e+01          rsw=100                   rdw=772
+ prwg=0                    prwb=0                    wr=1
+ alpha0=6.3669e-008        alpha1=1.7728             beta0=28.5
+ agidl=1e-007+dagidln_hv25_snw                       bgidl=6.0278256e+009+dbgidln_hv25_snw
+ lbgidl=-577.16963+dlbgidln_hv25_snw                 wbgidl=-15283.336+dwbgidln_hv25_snw
+ pbgidl=0.0057465345+dpbgidln_hv25_snw               cgidl=21.599
+ egidl=0.55661             aigbacc=0.01238           bigbacc=0.006109
+ cigbacc=0.2809            nigbacc=4.05              aigbinv=0.35
+ bigbinv=0.03              cigbinv=0.006             eigbinv=1.1
+ nigbinv=1                 aigc=0.009898             bigc=0.001383
+ cigc=1.515e-005           aigsd=0.0086              bigsd=0.0004353
+ cigsd=3.925e-020          nigc=1                    poxedge=1
+ pigcd=1.672               ntox=1                    xrcrg1=12
+ xrcrg2=1                  cgso=cgson_hv25_snw       cgdo=cgdon_hv25_snw
+ cgbo=0                    cgdl=cgdln_hv25_snw       cgsl=cgsln_hv25_snw
+ clc=1e-007                cle=0.6                   cf=cfn_hv25_snw
+ ckappas=0.6               ckappad=0.6               acde=0.5
+ moin=5.2                  noff=2.3652               voffcv=-0.27608
+ tvoff=0.001               ltvoff=0                  wtvoff=0
+ ptvoff=0                  kt1=-0.3639965+dkt1n_hv25_snw
+ lkt1=3.0229093e-008+dlkt1n_hv25_snw                 wkt1=4.2878905e-007+dwkt1n_hv25_snw
+ pkt1=-1.8295756e-013+dpkt1n_hv25_snw                kt1l=0
+ kt2=-0.066333             ute=-1.5                  ua1=3.6376575e-009
+ lua1=-4.9998898e-016      wua1=-1.5236981e-014      pua1=5.7193303e-021
+ ub1=-3.371599e-018        lub1=1.3607427e-025       wub1=2.3649905e-024
+ pub1=-1.3607427e-030      uc1=3.2503237e-010        luc1=-1.1291745e-016
+ wuc1=-6.0062184e-015      puc1=2.2583381e-021       prt=0
+ at=-150000+datn_hv25_snw  jss=1.850000e-07          jsws=3.310000e-13
+ jswgs=3.310000e-13        njs=1.02                  njd=1.02
+ ijthsfwd=0.01             ijthdfwd=0.01             ijthsrev=0.01
+ ijthdrev=0.01             bvs=9.300000e+00          xjbvs=1
+ xjbvd=1                   jsd=9.604700e-07          jswd=7.784700e-13
+ jswgd=7.784700e-13        bvd=1.410000e+01          jtsswgs=1e-010+djtsswgsn_hv25_snw
+ jtsswgd=1e-008+djtsswgdn_hv25_snw                   njtsswg=5.8+dnjtsswgn_hv25_snw
+ xtsswgs=0.1               xtsswgd=0.36533           tnjtsswg=1
+ vtsswgs=1                 vtsswgd=1                 pbs=7.800000e-01
+ cjs=cjsn_hv25_snw         mjs=2.900000e-01          pbsws=5.200000e-01
+ cjsws=cjswsn_hv25_snw     mjsws=9.300000e-02        pbswgs=5.500000e-01
+ cjswgs=cjswgsn_hv25_snw   mjswgs=2.200000e-01       pbd=6.000000e-01
+ cjd=cjdn_hv25_snw         mjd=3.600000e-01          pbswd=6.500000e-01
+ cjswd=cjswdn_hv25_snw     mjswd=2.800000e-01        pbswgd=7.000000e-01
+ cjswgd=cjswgdn_hv25_snw   mjswgd=3.300000e-01       tpb=2.200000e-03
+ tcj=2.000000e-03          tpbsw=2.000000e-03        tcjsw=1.160000e-03
+ tpbswg=2.500000e-03       tcjswg=1.640000e-03       xtis=3
+ xtid=3                    dmcg=5.800000e-08         dmci=5.800000e-08
+ dmdg=0                    dmcgt=0                   dwj=0
+ xgw=0                     xgl=-1.090000e-08         rshg=1.560000e+01
+ gbmin=1e-012              rbpb=50                   rbpd=50
+ rbps=50                   rbdb=50                   rbsb=50
+ ngcon=1                   lnfactor=0+dlnfactorn_hv25_snw
+ wnfactor=0+dwnfactorn_hv25_snw                      pnfactor=0+dpnfactorn_hv25_snw
+ lagidl=0+dlagidln_hv25_snw                          wagidl=0+dwagidln_hv25_snw
+ pagidl=0+dpagidln_hv25_snw                          wat=0+dwatn_hv25_snw
+ lat=0+dlatn_hv25_snw      pat=0+dpatn_hv25_snw      wvsat=0+dwvsatn_hv25_snw
+ minr=1e-3

     7: type=n
+ lmin=1e-005-dxln_hv25_snw lmax=0.000900001          wmin=5e-006-dxwn_hv25_snw
+ wmax=1e-005-dxwn_hv25_snw version=4.5               binunit=2
+ paramchk=1                mobmod=0                  capmod=2
+ igcmod=0                  igbmod=0                  diomod=1
+ rdsmod=1                  rbodymod=0                rgeomod=1
+ rgatemod=1*rgflag_hv25_snw_spw                      permod=1
+ acnqsmod=0                trnqsmod=0                tempmod=0
+ tnom=25                   toxe=toxn_hv25_snw        toxm=5.7e-009
+ dtox=3.1372e-010          epsrox=3.9                wint=0
+ lint=2.23e-007            ll=0                      wl=0
+ lln=1                     wln=1                     lw=0
+ ww=0                      lwn=1                     wwn=1
+ lwl=0                     wwl=0                     llc=0
+ wlc=0                     lwc=0                     wwc=0
+ lwlc=0                    wwlc=0                    xl=2.2e-08+dxln_hv25_snw
+ xw=0+dxwn_hv25_snw        dlc=ddlcn_hv25_snw        dwc=0
+ xpart=1                   toxref=3e-009             dlcig=2.5e-009
+ vth0=0.53044+dvthn_hv25_snw                         wvth0=4.76e-008+dwvthn_hv25_snw
+ k1=0.33827                k2=0.1498+dk2n_hv25_snw   wk2=-5.9e-008+dwk2n_hv25_snw
+ k3=-1.82                  k3b=1.0692                w0=0
+ dvt0=2                    dvt1=0.0055               dvt2=0.0087
+ dvt0w=0                   dvt1w=0                   dvt2w=0
+ dsub=0.22592              minv=-0.4484              voffl=-5e-009
+ dvtp0=2.1516e-007         dvtp1=0.01                lpe0=5.3147e-007
+ lpeb=1e-011               xj=6.7e-008               ngate=8.5997e+020
+ ndep=9e+017               nsd=1e+020                phin=0.185
+ cdsc=0                    cdscb=0                   cdscd=0
+ cit=0.00059996+dcitn_hv25_snw                       wcit=2.0012e-009+dwcitn_hv25_snw
+ voff=-0.13289+dvoffn_hv25_snw                       wvoff=3.86e-008+dwvoffn_hv25_snw
+ nfactor=0.6+dnfactorn_hv25_snw                      eta0=0.012+deta0n_hv25_snw
+ etab=-0.0600378           wetab=7.3127e-008         ud=0
+ lud=0                     wud=0                     pud=0
+ u0=0.04+du0n_hv25_snw     ua=1.204e-010+duan_hv25_snw
+ lua=3.8716134e-023+dluan_hv25_snw                   wua=-4e-016+dwuan_hv25_snw
+ pua=-1.9358067e-028+dpuan_hv25_snw                  ub=2.1005e-018+dubn_hv25_snw
+ wub=1.486e-024+dwubn_hv25_snw                       uc=1.7704e-010
+ luc=-9.6790334e-023       wuc=-5.3100001e-017       puc=9.6790334e-028
+ vsat=140000+dvsatn_hv25_snw                         a0=-0.00841
+ la0=-2.90371e-014         wa0=-2.775e-007           pa0=6.8243725e-028
+ ags=1.18056+dagsn_hv25_snw                          wags=-1.1146e-006+dwagsn_hv25_snw
+ a1=0                      a2=1                      b0=0
+ b1=0                      keta=-0.045428+dketan_hv25_snw
+ wketa=4.438e-008+dwketan_hv25_snw                   dwg=0
+ dwb=0                     pclm=0.01                 pdiblc1=0
+ pdiblc2=4.9918e-005       wpdiblc2=4.1e-013         pdiblcb=0
+ drout=0.56                pvag=0.45                 delta=0.01
+ pscbe1=9.264e+008         pscbe2=1e-020             fprout=750
+ pdits=0                   pditsd=0                  pditsl=0
+ rsh=1.750000e+01          rsw=100                   rdw=772
+ prwg=0                    prwb=0                    wr=1
+ alpha0=6.3669e-008        alpha1=1.7728             beta0=28.5
+ agidl=1e-007+dagidln_hv25_snw                       bgidl=4.5411657e+009+dbgidln_hv25_snw
+ lbgidl=0.00096790334+dlbgidln_hv25_snw              wbgidl=-460.42099+dwbgidln_hv25_snw
+ pbgidl=-9.6790334e-009+dpbgidln_hv25_snw            cgidl=21.599
+ egidl=0.55661             aigbacc=0.01238           bigbacc=0.006109
+ cigbacc=0.2809            nigbacc=4.05              aigbinv=0.35
+ bigbinv=0.03              cigbinv=0.006             eigbinv=1.1
+ nigbinv=1                 aigc=0.009898             bigc=0.001383
+ cigc=1.515e-005           aigsd=0.0086              bigsd=0.0004353
+ cigsd=3.925e-020          nigc=1                    poxedge=1
+ pigcd=1.672               ntox=1                    xrcrg1=12
+ xrcrg2=1                  cgso=cgson_hv25_snw       cgdo=cgdon_hv25_snw
+ cgbo=0                    cgdl=cgdln_hv25_snw       cgsl=cgsln_hv25_snw
+ clc=1e-007                cle=0.6                   cf=cfn_hv25_snw
+ ckappas=0.6               ckappad=0.6               acde=0.5
+ moin=5.2                  noff=2.3652               voffcv=-0.27608
+ tvoff=0.001               ltvoff=0                  wtvoff=0
+ ptvoff=0                  kt1=-0.3004023+dkt1n_hv25_snw
+ wkt1=2.3e-011+dwkt1n_hv25_snw                       kt1l=0
+ kt2=-0.066333             ute=-1.5                  ua1=2.0819877e-009
+ wua1=1.568746e-015        ub1=-3.1351e-018          uc1=-1.8382824e-010
+ wuc1=1.0427412e-015       prt=0                     at=-150000+datn_hv25_snw
+ jss=1.850000e-07          jsws=3.310000e-13         jswgs=3.310000e-13
+ njs=1.02                  njd=1.02                  ijthsfwd=0.01
+ ijthdfwd=0.01             ijthsrev=0.01             ijthdrev=0.01
+ bvs=9.300000e+00          xjbvs=1                   xjbvd=1
+ jsd=9.604700e-07          jswd=7.784700e-13         jswgd=7.784700e-13
+ bvd=1.410000e+01          jtsswgs=1e-010+djtsswgsn_hv25_snw
+ jtsswgd=1e-008+djtsswgdn_hv25_snw                   njtsswg=5.8+dnjtsswgn_hv25_snw
+ xtsswgs=0.1               xtsswgd=0.36533           tnjtsswg=1
+ vtsswgs=1                 vtsswgd=1                 pbs=7.800000e-01
+ cjs=cjsn_hv25_snw         mjs=2.900000e-01          pbsws=5.200000e-01
+ cjsws=cjswsn_hv25_snw     mjsws=9.300000e-02        pbswgs=5.500000e-01
+ cjswgs=cjswgsn_hv25_snw   mjswgs=2.200000e-01       pbd=6.000000e-01
+ cjd=cjdn_hv25_snw         mjd=3.600000e-01          pbswd=6.500000e-01
+ cjswd=cjswdn_hv25_snw     mjswd=2.800000e-01        pbswgd=7.000000e-01
+ cjswgd=cjswgdn_hv25_snw   mjswgd=3.300000e-01       tpb=2.200000e-03
+ tcj=2.000000e-03          tpbsw=2.000000e-03        tcjsw=1.160000e-03
+ tpbswg=2.500000e-03       tcjswg=1.640000e-03       xtis=3
+ xtid=3                    dmcg=5.800000e-08         dmci=5.800000e-08
+ dmdg=0                    dmcgt=0                   dwj=0
+ xgw=0                     xgl=-1.090000e-08         rshg=1.560000e+01
+ gbmin=1e-012              rbpb=50                   rbpd=50
+ rbps=50                   rbdb=50                   rbsb=50
+ ngcon=1                   pketa=0+dpketan_hv25_snw  lketa=0+dlketan_hv25_snw
+ lvth0=0+dlvthn_hv25_snw   pvth0=0+dpvthn_hv25_snw   lk2=0+dlk2n_hv25_snw
+ pk2=0+dpk2n_hv25_snw      lcit=0+dlcitn_hv25_snw    pcit=0+dpcitn_hv25_snw
+ lvoff=0+dlvoffn_hv25_snw  pvoff=0+dpvoffn_hv25_snw  lu0=0+dlu0n_hv25_snw
+ wu0=0+dwu0n_hv25_snw      pu0=0+dpu0n_hv25_snw      lnfactor=0+dlnfactorn_hv25_snw
+ wnfactor=0+dwnfactorn_hv25_snw                      pnfactor=0+dpnfactorn_hv25_snw
+ lub=0+dlubn_hv25_snw      pub=0+dpubn_hv25_snw      lags=0+dlagsn_hv25_snw
+ pags=0+dpagsn_hv25_snw    lagidl=0+dlagidln_hv25_snw
+ wagidl=0+dwagidln_hv25_snw                          pagidl=0+dpagidln_hv25_snw
+ lkt1=0+dlkt1n_hv25_snw    pkt1=0+dpkt1n_hv25_snw    wat=0+dwatn_hv25_snw
+ lat=0+dlatn_hv25_snw      pat=0+dpatn_hv25_snw      weta0=0+dweta0n_hv25_snw
+ wvsat=0+dwvsatn_hv25_snw  minr=1e-3

     8: type=n
+ lmin=1e-006-dxln_hv25_snw lmax=1e-005-dxln_hv25_snw wmin=5e-006-dxwn_hv25_snw
+ wmax=1e-005-dxwn_hv25_snw version=4.5               binunit=2
+ paramchk=1                mobmod=0                  capmod=2
+ igcmod=0                  igbmod=0                  diomod=1
+ rdsmod=1                  rbodymod=0                rgeomod=1
+ rgatemod=1*rgflag_hv25_snw_spw                      permod=1
+ acnqsmod=0                trnqsmod=0                tempmod=0
+ tnom=25                   toxe=toxn_hv25_snw        toxm=5.7e-009
+ dtox=3.1372e-010          epsrox=3.9                wint=0
+ lint=2.23e-007            ll=0                      wl=0
+ lln=1                     wln=1                     lw=0
+ ww=0                      lwn=1                     wwn=1
+ lwl=0                     wwl=0                     llc=0
+ wlc=0                     lwc=0                     wwc=0
+ lwlc=0                    wwlc=0                    xl=2.2e-08+dxln_hv25_snw
+ xw=0+dxwn_hv25_snw        dlc=ddlcn_hv25_snw        dwc=0
+ xpart=1                   toxref=3e-009             dlcig=2.5e-009
+ vth0=0.5188056+dvthn_hv25_snw                       lvth0=1.1141104e-007+dlvthn_hv25_snw
+ wvth0=5.0063155e-008+dwvthn_hv25_snw                pvth0=-2.3587174e-014+dpvthn_hv25_snw
+ k1=0.33827                k2=0.14979959+dk2n_hv25_snw
+ lk2=3.9284582e-012+dlk2n_hv25_snw                   wk2=-5.8996678e-008+dwk2n_hv25_snw
+ pk2=-3.1807642e-017+dpk2n_hv25_snw                  k3=-1.82
+ k3b=1.0692                w0=0                      dvt0=2
+ dvt1=0.0055               dvt2=0.0087               dvt0w=0
+ dvt1w=0                   dvt2w=0                   dsub=0.22592
+ minv=-0.4484              voffl=-5e-009             dvtp0=2.1516e-007
+ dvtp1=0.01                lpe0=5.3147e-007          lpeb=1e-011
+ xj=6.7e-008               ngate=8.5997e+020         ndep=9e+017
+ nsd=1e+020                phin=0.185                cdsc=0
+ cdscb=0                   cdscd=0                   cit=0.00059996273+dcitn_hv25_snw
+ lcit=-2.6144778e-014+dlcitn_hv25_snw                wcit=2.001171e-009+dwcitn_hv25_snw
+ pcit=2.7750482e-019+dpcitn_hv25_snw                 voff=-0.13371092+dvoffn_hv25_snw
+ lvoff=7.8611085e-009+dlvoffn_hv25_snw               wvoff=4.4252038e-008+dwvoffn_hv25_snw
+ pvoff=-5.412392e-014+dpvoffn_hv25_snw               nfactor=0.6+dnfactorn_hv25_snw
+ eta0=0.012+deta0n_hv25_snw                          leta0=1.225728e-015
+ weta0=6.4000002e-016+dweta0n_hv25_snw               peta0=-6.12864e-021
+ etab=-0.0600378           wetab=7.3127e-008         ud=0
+ lud=0                     wud=0                     pud=0
+ u0=0.039359894+du0n_hv25_snw                        lu0=6.1296543e-009+dlu0n_hv25_snw
+ wu0=1.05856e-012+dwu0n_hv25_snw                     pu0=-1.0136771e-017+dpu0n_hv25_snw
+ ua=1.2039804e-010+duan_hv25_snw                     lua=1.8787959e-020+dluan_hv25_snw
+ wua=-3.9998684e-016+dwuan_hv25_snw                  pua=-1.2625611e-025+dpuan_hv25_snw
+ ub=2.0974298e-018+dubn_hv25_snw                     lub=2.940068e-026+dlubn_hv25_snw
+ wub=1.5549496e-024+dwubn_hv25_snw                   pub=-6.6026168e-031+dpubn_hv25_snw
+ uc=1.7704021e-010         luc=-2.1082522e-021       wuc=-5.3101372e-017
+ puc=1.4095872e-026        vsat=140000+dvsatn_hv25_snw
+ a0=0.023593776            la0=-3.0646819e-007       wa0=-2.3670116e-007
+ pa0=-3.9068971e-013       ags=1.1805538+dagsn_hv25_snw
+ lags=5.9147505e-011+dlagsn_hv25_snw                 wags=-1.1145691e-006+dwagsn_hv25_snw
+ pags=-2.9546173e-016+dpagsn_hv25_snw                a1=0
+ a2=1                      b0=0                      b1=0
+ keta=-0.045427952+dketan_hv25_snw                   lketa=-4.6393805e-013+dlketan_hv25_snw
+ wketa=4.4379823e-008+dwketan_hv25_snw               pketa=1.6976333e-018+dpketan_hv25_snw
+ dwg=0                     dwb=0                     pclm=0.01
+ pdiblc1=0                 pdiblc2=4.9918039e-005    lpdiblc2=-3.6894413e-016
+ wpdiblc2=4.0980736e-013   ppdiblc2=1.8447206e-021   pdiblcb=0
+ drout=0.56                pvag=0.45                 delta=0.01
+ pscbe1=9.264e+008         pscbe2=1e-020             fprout=750
+ pdits=0                   pditsd=0                  pditsl=0
+ rsh=1.750000e+01          rsw=100                   rdw=772
+ prwg=0                    prwb=0                    wr=1
+ alpha0=6.3669e-008        alpha1=1.7728             beta0=28.5
+ agidl=1e-007+dagidln_hv25_snw                       bgidl=4.5411658e+009+dbgidln_hv25_snw
+ wbgidl=-460.422+dwbgidln_hv25_snw                   cgidl=21.599
+ egidl=0.55661             aigbacc=0.01238           bigbacc=0.006109
+ cigbacc=0.2809            nigbacc=4.05              aigbinv=0.35
+ bigbinv=0.03              cigbinv=0.006             eigbinv=1.1
+ nigbinv=1                 aigc=0.009898             bigc=0.001383
+ cigc=1.515e-005           aigsd=0.0086              bigsd=0.0004353
+ cigsd=3.925e-020          nigc=1                    poxedge=1
+ pigcd=1.672               ntox=1                    xrcrg1=12
+ xrcrg2=1                  cgso=cgson_hv25_snw       cgdo=cgdon_hv25_snw
+ cgbo=0                    cgdl=cgdln_hv25_snw       cgsl=cgsln_hv25_snw
+ clc=1e-007                cle=0.6                   cf=cfn_hv25_snw
+ ckappas=0.6               ckappad=0.6               acde=0.5
+ moin=5.2                  noff=2.3652               voffcv=-0.27608
+ tvoff=0.001               ltvoff=0                  wtvoff=0
+ ptvoff=0                  kt1=-0.3004023+dkt1n_hv25_snw
+ wkt1=2.3e-011+dwkt1n_hv25_snw                       kt1l=0
+ kt2=-0.066333             ute=-1.5                  ua1=2.0819877e-009
+ wua1=1.568746e-015        ub1=-3.1351e-018          uc1=-1.8382824e-010
+ wuc1=1.0427412e-015       prt=0                     at=-150000+datn_hv25_snw
+ jss=1.850000e-07          jsws=3.310000e-13         jswgs=3.310000e-13
+ njs=1.02                  njd=1.02                  ijthsfwd=0.01
+ ijthdfwd=0.01             ijthsrev=0.01             ijthdrev=0.01
+ bvs=9.300000e+00          xjbvs=1                   xjbvd=1
+ jsd=9.604700e-07          jswd=7.784700e-13         jswgd=7.784700e-13
+ bvd=1.410000e+01          jtsswgs=1e-010+djtsswgsn_hv25_snw
+ jtsswgd=1e-008+djtsswgdn_hv25_snw                   njtsswg=5.8+dnjtsswgn_hv25_snw
+ xtsswgs=0.1               xtsswgd=0.36533           tnjtsswg=1
+ vtsswgs=1                 vtsswgd=1                 pbs=7.800000e-01
+ cjs=cjsn_hv25_snw         mjs=2.900000e-01          pbsws=5.200000e-01
+ cjsws=cjswsn_hv25_snw     mjsws=9.300000e-02        pbswgs=5.500000e-01
+ cjswgs=cjswgsn_hv25_snw   mjswgs=2.200000e-01       pbd=6.000000e-01
+ cjd=cjdn_hv25_snw         mjd=3.600000e-01          pbswd=6.500000e-01
+ cjswd=cjswdn_hv25_snw     mjswd=2.800000e-01        pbswgd=7.000000e-01
+ cjswgd=cjswgdn_hv25_snw   mjswgd=3.300000e-01       tpb=2.200000e-03
+ tcj=2.000000e-03          tpbsw=2.000000e-03        tcjsw=1.160000e-03
+ tpbswg=2.500000e-03       tcjswg=1.640000e-03       xtis=3
+ xtid=3                    dmcg=5.800000e-08         dmci=5.800000e-08
+ dmdg=0                    dmcgt=0                   dwj=0
+ xgw=0                     xgl=-1.090000e-08         rshg=1.560000e+01
+ gbmin=1e-012              rbpb=50                   rbpd=50
+ rbps=50                   rbdb=50                   rbsb=50
+ ngcon=1                   lnfactor=0+dlnfactorn_hv25_snw
+ wnfactor=0+dwnfactorn_hv25_snw                      pnfactor=0+dpnfactorn_hv25_snw
+ lagidl=0+dlagidln_hv25_snw                          wagidl=0+dwagidln_hv25_snw
+ pagidl=0+dpagidln_hv25_snw                          lbgidl=0+dlbgidln_hv25_snw
+ pbgidl=0+dpbgidln_hv25_snw                          lkt1=0+dlkt1n_hv25_snw
+ pkt1=0+dpkt1n_hv25_snw    wat=0+dwatn_hv25_snw      lat=0+dlatn_hv25_snw
+ pat=0+dpatn_hv25_snw      wvsat=0+dwvsatn_hv25_snw  minr=1e-3

     9: type=n
+ lmin=7.92e-07             lmax=1e-006-dxln_hv25_snw wmin=5e-006-dxwn_hv25_snw
+ wmax=1e-005-dxwn_hv25_snw version=4.5               binunit=2
+ paramchk=1                mobmod=0                  capmod=2
+ igcmod=0                  igbmod=0                  diomod=1
+ rdsmod=1                  rbodymod=0                rgeomod=1
+ rgatemod=1*rgflag_hv25_snw_spw                      permod=1
+ acnqsmod=0                trnqsmod=0                tempmod=0
+ tnom=25                   toxe=toxn_hv25_snw        toxm=5.7e-009
+ dtox=3.1372e-010          epsrox=3.9                wint=0
+ lint=2.23e-007            ll=0                      wl=0
+ lln=1                     wln=1                     lw=0
+ ww=0                      lwn=1                     wwn=1
+ lwl=0                     wwl=0                     llc=0
+ wlc=0                     lwc=0                     wwc=0
+ lwlc=0                    wwlc=0                    xl=2.2e-08+dxln_hv25_snw
+ xw=0+dxwn_hv25_snw        dlc=ddlcn_hv25_snw        dwc=0
+ xpart=1                   toxref=3e-009             dlcig=2.5e-009
+ vth0=0.75288734+dvthn_hv25_snw                      lvth0=-2.3420041e-008+dlvthn_hv25_snw
+ wvth0=3.6398016e-008+dwvthn_hv25_snw                pvth0=-1.5716054e-014+dpvthn_hv25_snw
+ k1=0.33827                k2=0.15884246+dk2n_hv25_snw
+ lk2=-5.2047653e-009+dlk2n_hv25_snw                  wk2=-1.2720547e-007+dwk2n_hv25_snw
+ pk2=3.9256457e-014+dpk2n_hv25_snw                   k3=-1.82
+ k3b=1.0692                w0=0                      dvt0=2
+ dvt1=0.0055               dvt2=0.0087               dvt0w=0
+ dvt1w=0                   dvt2w=0                   dsub=0.22592
+ minv=-0.4484              voffl=-5e-009             dvtp0=2.1516e-007
+ dvtp1=0.01                lpe0=5.3147e-007          lpeb=1e-011
+ xj=6.7e-008               ngate=8.5997e+020         ndep=9e+017
+ nsd=1e+020                phin=0.185                cdsc=0
+ cdscb=0                   cdscd=0                   cit=0.0013517619+dcitn_hv25_snw
+ lcit=-4.3306249e-010+dlcitn_hv25_snw                wcit=5.7647601e-009+dwcitn_hv25_snw
+ pcit=-2.1675498e-015+dpcitn_hv25_snw                voff=-0.1483819+dvoffn_hv25_snw
+ lvoff=1.6311595e-008+dlvoffn_hv25_snw               wvoff=-4.9173728e-008+dwvoffn_hv25_snw
+ pvoff=-3.1067827e-016+dpvoffn_hv25_snw              nfactor=0.6+dnfactorn_hv25_snw
+ eta0=-0.0030399942+deta0n_hv25_snw                  leta0=8.6630378e-009
+ weta0=-2.88e-014+dweta0n_hv25_snw                   peta0=1.08288e-020
+ etab=-0.0600378           wetab=7.3127e-008         ud=0
+ lud=0                     wud=0                     pud=0
+ u0=0.046244766+du0n_hv25_snw                        lu0=2.1639678e-009+dlu0n_hv25_snw
+ wu0=-1.8847635e-008+dwu0n_hv25_snw                  pu0=1.0846711e-014+dpu0n_hv25_snw
+ ua=-7.2806876e-010+duan_hv25_snw                    lua=4.8873567e-016+dluan_hv25_snw
+ wua=7.5987762e-017+dwuan_hv25_snw                   pua=-2.7428762e-022+dpuan_hv25_snw
+ ub=2.3420611e-018+dubn_hv25_snw                     lub=-1.1150697e-025+dlubn_hv25_snw
+ wub=8.466656e-026+dwubn_hv25_snw                    pub=1.8662137e-031+dpubn_hv25_snw
+ uc=3.7198984e-010         luc=-1.122931e-016        wuc=-2.5754728e-017
+ puc=-1.5737571e-023       vsat=140000+dvsatn_hv25_snw
+ a0=0.92020114             la0=-8.2291403e-007       wa0=-4.9043079e-006
+ pa0=2.2978518e-012        ags=1.0397628+dagsn_hv25_snw
+ lags=8.1154806e-008+dlagsn_hv25_snw                 wags=-5.1948365e-006+dwagsn_hv25_snw
+ pags=2.3499385e-012+dpagsn_hv25_snw                 a1=0
+ a2=1                      b0=0                      b1=0
+ keta=-0.13695439+dketan_hv25_snw                    lketa=5.2718764e-008+dlketan_hv25_snw
+ wketa=1.6293693e-007+dwketan_hv25_snw               pketa=-6.8287195e-014+dpketan_hv25_snw
+ dwg=0                     dwb=0                     pclm=-0.084
+ lpclm=5.4144e-008         pdiblc1=0                 pdiblc2=-0.00079623789
+ lpdiblc2=4.8738545e-010   wpdiblc2=-1.8788105e-009  ppdiblc2=1.0824328e-015
+ pdiblcb=0                 drout=0.56                pvag=0.45
+ delta=0.01                pscbe1=9.264e+008         pscbe2=1e-020
+ fprout=750                pdits=0                   pditsd=0
+ pditsl=0                  rsh=1.750000e+01          rsw=100
+ rdw=772                   prwg=0                    prwb=0
+ wr=1                      alpha0=6.3669e-008        alpha1=1.7728
+ beta0=28.5                agidl=1e-007+dagidln_hv25_snw
+ bgidl=4.6320935e+009+dbgidln_hv25_snw               lbgidl=-52.374357+dlbgidln_hv25_snw
+ wbgidl=-1326.0154+dwbgidln_hv25_snw                 pbgidl=0.00049858177+dpbgidln_hv25_snw
+ cgidl=21.599              egidl=0.55661             aigbacc=0.01238
+ bigbacc=0.006109          cigbacc=0.2809            nigbacc=4.05
+ aigbinv=0.35              bigbinv=0.03              cigbinv=0.006
+ eigbinv=1.1               nigbinv=1                 aigc=0.009898
+ bigc=0.001383             cigc=1.515e-005           aigsd=0.0086
+ bigsd=0.0004353           cigsd=3.925e-020          nigc=1
+ poxedge=1                 pigcd=1.672               ntox=1
+ xrcrg1=12                 xrcrg2=1                  cgso=cgson_hv25_snw
+ cgdo=cgdon_hv25_snw       cgbo=0                    cgdl=cgdln_hv25_snw
+ cgsl=cgsln_hv25_snw       clc=1e-007                cle=0.6
+ cf=cfn_hv25_snw           ckappas=0.6               ckappad=0.6
+ acde=0.5                  moin=5.2                  noff=2.3652
+ voffcv=-0.27608           tvoff=0.001               ltvoff=0
+ wtvoff=0                  ptvoff=0                  kt1=-0.32616262+dkt1n_hv25_snw
+ lkt1=1.4837947e-008+dlkt1n_hv25_snw                 wkt1=5.045024e-008+dwkt1n_hv25_snw
+ pkt1=-2.904609e-014+dpkt1n_hv25_snw                 kt1l=0
+ kt2=-0.066333             ute=-1.5                  ua1=1.8313606e-009
+ lua1=1.4436122e-016       wua1=2.8259885e-015       pua1=-7.2417167e-022
+ ub1=-3.1351e-018          uc1=-5.7589893e-010       luc1=2.2583272e-016
+ wuc1=3.0030947e-015       puc1=-1.1291636e-021      prt=0
+ at=-150000+datn_hv25_snw  jss=1.850000e-07          jsws=3.310000e-13
+ jswgs=3.310000e-13        njs=1.02                  njd=1.02
+ ijthsfwd=0.01             ijthdfwd=0.01             ijthsrev=0.01
+ ijthdrev=0.01             bvs=9.300000e+00          xjbvs=1
+ xjbvd=1                   jsd=9.604700e-07          jswd=7.784700e-13
+ jswgd=7.784700e-13        bvd=1.410000e+01          jtsswgs=1e-010+djtsswgsn_hv25_snw
+ jtsswgd=1e-008+djtsswgdn_hv25_snw                   njtsswg=5.8+dnjtsswgn_hv25_snw
+ xtsswgs=0.1               xtsswgd=0.36533           tnjtsswg=1
+ vtsswgs=1                 vtsswgd=1                 pbs=7.800000e-01
+ cjs=cjsn_hv25_snw         mjs=2.900000e-01          pbsws=5.200000e-01
+ cjsws=cjswsn_hv25_snw     mjsws=9.300000e-02        pbswgs=5.500000e-01
+ cjswgs=cjswgsn_hv25_snw   mjswgs=2.200000e-01       pbd=6.000000e-01
+ cjd=cjdn_hv25_snw         mjd=3.600000e-01          pbswd=6.500000e-01
+ cjswd=cjswdn_hv25_snw     mjswd=2.800000e-01        pbswgd=7.000000e-01
+ cjswgd=cjswgdn_hv25_snw   mjswgd=3.300000e-01       tpb=2.200000e-03
+ tcj=2.000000e-03          tpbsw=2.000000e-03        tcjsw=1.160000e-03
+ tpbswg=2.500000e-03       tcjswg=1.640000e-03       xtis=3
+ xtid=3                    dmcg=5.800000e-08         dmci=5.800000e-08
+ dmdg=0                    dmcgt=0                   dwj=0
+ xgw=0                     xgl=-1.090000e-08         rshg=1.560000e+01
+ gbmin=1e-012              rbpb=50                   rbpd=50
+ rbps=50                   rbdb=50                   rbsb=50
+ ngcon=1                   lnfactor=0+dlnfactorn_hv25_snw
+ wnfactor=0+dwnfactorn_hv25_snw                      pnfactor=0+dpnfactorn_hv25_snw
+ lagidl=0+dlagidln_hv25_snw                          wagidl=0+dwagidln_hv25_snw
+ pagidl=0+dpagidln_hv25_snw                          wat=0+dwatn_hv25_snw
+ lat=0+dlatn_hv25_snw      pat=0+dpatn_hv25_snw      wvsat=0+dwvsatn_hv25_snw
+ minr=1e-3

     10: type=n
+ lmin=1e-005-dxln_hv25_snw lmax=0.000900001          wmin=1e-06
+ wmax=5e-006-dxwn_hv25_snw version=4.5               binunit=2
+ paramchk=1                mobmod=0                  capmod=2
+ igcmod=0                  igbmod=0                  diomod=1
+ rdsmod=1                  rbodymod=0                rgeomod=1
+ rgatemod=1*rgflag_hv25_snw_spw                      permod=1
+ acnqsmod=0                trnqsmod=0                tempmod=0
+ tnom=25                   toxe=toxn_hv25_snw        toxm=5.7e-009
+ dtox=3.1372e-010          epsrox=3.9                wint=0
+ lint=2.23e-007            ll=0                      wl=0
+ lln=1                     wln=1                     lw=0
+ ww=0                      lwn=1                     wwn=1
+ lwl=0                     wwl=0                     llc=0
+ wlc=0                     lwc=0                     wwc=0
+ lwlc=0                    wwlc=0                    xl=2.2e-08+dxln_hv25_snw
+ xw=0+dxwn_hv25_snw        dlc=ddlcn_hv25_snw        dwc=0
+ xpart=1                   toxref=3e-009             dlcig=2.5e-009
+ vth0=0.5400175+dvthn_hv25_snw                       wvth0=-2.875e-010+dwvthn_hv25_snw
+ k1=0.33827                k2=0.1376775+dk2n_hv25_snw
+ wk2=1.6125e-009+dwk2n_hv25_snw                      k3=-1.82
+ k3b=1.0692                w0=0                      dvt0=2
+ dvt1=0.0055               dvt2=0.0087               dvt0w=0
+ dvt1w=0                   dvt2w=0                   dsub=0.22592
+ minv=-0.4484              voffl=-5e-009             dvtp0=2.1516e-007
+ dvtp1=0.01                lpe0=5.3147e-007          lpeb=1e-011
+ xj=6.7e-008               ngate=8.5997e+020         ndep=9e+017
+ nsd=1e+020                phin=0.185                cdsc=0
+ cdscb=0                   cdscd=0                   cit=0.0010752925+dcitn_hv25_snw
+ lcit=1.2098792e-016+dlcitn_hv25_snw                 wcit=-3.754625e-010+dwcitn_hv25_snw
+ pcit=-6.0493959e-022+dpcitn_hv25_snw                voff=-0.1255275+dvoffn_hv25_snw
+ wvoff=1.7875e-009+dwvoffn_hv25_snw                  nfactor=0.6+dnfactorn_hv25_snw
+ eta0=0.01+deta0n_hv25_snw weta0=1e-008+dweta0n_hv25_snw
+ etab=-0.04756895          wetab=1.078275e-008       ud=0
+ lud=0                     wud=0                     pud=0
+ u0=0.041+du0n_hv25_snw    wu0=-5e-009+dwu0n_hv25_snw
+ ua=3.73e-011+duan_hv25_snw                          lua=2.4197583e-024+dluan_hv25_snw
+ wua=1.55e-017+dwuan_hv25_snw                        pua=-1.2098792e-029+dpuan_hv25_snw
+ ub=2.57595e-018+dubn_hv25_snw                       wub=-8.9125e-025+dwubn_hv25_snw
+ uc=1.810025e-010          luc=9.6790334e-023        wuc=-7.29125e-017
+ puc=-2.2817674e-037       vsat=140000+dvsatn_hv25_snw
+ a0=-0.046215              la0=-3.6296375e-014       wa0=-8.8475e-008
+ pa0=3.6296375e-020        ags=0.94705+dagsn_hv25_snw
+ wags=5.295e-008+dwagsn_hv25_snw                     a1=0
+ a2=1                      b0=0                      b1=0
+ keta=-0.03639625+dketan_hv25_snw                    wketa=-7.7875e-010+dwketan_hv25_snw
+ dwg=0                     dwb=0                     pclm=0.01
+ pdiblc1=0                 pdiblc2=5e-005            pdiblcb=0
+ drout=0.56                pvag=0.45                 delta=0.01
+ pscbe1=9.264e+008         pscbe2=1e-020             fprout=750
+ pdits=0                   pditsd=0                  pditsl=0
+ rsh=1.750000e+01          rsw=100                   rdw=772
+ prwg=0                    prwb=0                    wr=1
+ alpha0=6.3669e-008        alpha1=1.7728             beta0=28.5
+ agidl=1e-007+dagidln_hv25_snw                       bgidl=4.4810019e+009+dbgidln_hv25_snw
+ lbgidl=-0.00096790333+dlbgidln_hv25_snw             wbgidl=-159.60175+dwbgidln_hv25_snw
+ pbgidl=-1.3786139e-017+dpbgidln_hv25_snw            cgidl=21.599
+ egidl=0.55661             aigbacc=0.01238           bigbacc=0.006109
+ cigbacc=0.2809            nigbacc=4.05              aigbinv=0.35
+ bigbinv=0.03              cigbinv=0.006             eigbinv=1.1
+ nigbinv=1                 aigc=0.009898             bigc=0.001383
+ cigc=1.515e-005           aigsd=0.0086              bigsd=0.0004353
+ cigsd=3.925e-020          nigc=1                    poxedge=1
+ pigcd=1.672               ntox=1                    xrcrg1=12
+ xrcrg2=1                  cgso=cgson_hv25_snw       cgdo=cgdon_hv25_snw
+ cgbo=0                    cgdl=cgdln_hv25_snw       cgsl=cgsln_hv25_snw
+ clc=1e-007                cle=0.6                   cf=cfn_hv25_snw
+ ckappas=0.6               ckappad=0.6               acde=0.5
+ moin=5.2                  noff=2.3652               voffcv=-0.27608
+ tvoff=0.001               ltvoff=0                  wtvoff=0
+ ptvoff=0                  kt1=-0.30178598+dkt1n_hv25_snw
+ wkt1=6.9413875e-009+dwkt1n_hv25_snw                 kt1l=0
+ kt2=-0.066333             ute=-1.5                  ua1=2.4526401e-009
+ wua1=-2.84516e-016        ub1=-3.1429185e-018       wub1=3.9092625e-026
+ uc1=2.472e-011            prt=0                     at=-150000+datn_hv25_snw
+ jss=1.850000e-07          jsws=3.310000e-13         jswgs=3.310000e-13
+ njs=1.02                  njd=1.02                  ijthsfwd=0.01
+ ijthdfwd=0.01             ijthsrev=0.01             ijthdrev=0.01
+ bvs=9.300000e+00          xjbvs=1                   xjbvd=1
+ jsd=9.604700e-07          jswd=7.784700e-13         jswgd=7.784700e-13
+ bvd=1.410000e+01          jtsswgs=1e-010+djtsswgsn_hv25_snw
+ jtsswgd=1e-008+djtsswgdn_hv25_snw                   njtsswg=5.8+dnjtsswgn_hv25_snw
+ xtsswgs=0.1               xtsswgd=0.36533           tnjtsswg=1
+ vtsswgs=1                 vtsswgd=1                 pbs=7.800000e-01
+ cjs=cjsn_hv25_snw         mjs=2.900000e-01          pbsws=5.200000e-01
+ cjsws=cjswsn_hv25_snw     mjsws=9.300000e-02        pbswgs=5.500000e-01
+ cjswgs=cjswgsn_hv25_snw   mjswgs=2.200000e-01       pbd=6.000000e-01
+ cjd=cjdn_hv25_snw         mjd=3.600000e-01          pbswd=6.500000e-01
+ cjswd=cjswdn_hv25_snw     mjswd=2.800000e-01        pbswgd=7.000000e-01
+ cjswgd=cjswgdn_hv25_snw   mjswgd=3.300000e-01       tpb=2.200000e-03
+ tcj=2.000000e-03          tpbsw=2.000000e-03        tcjsw=1.160000e-03
+ tpbswg=2.500000e-03       tcjswg=1.640000e-03       xtis=3
+ xtid=3                    dmcg=5.800000e-08         dmci=5.800000e-08
+ dmdg=0                    dmcgt=0                   dwj=0
+ xgw=0                     xgl=-1.090000e-08         rshg=1.560000e+01
+ gbmin=1e-012              rbpb=50                   rbpd=50
+ rbps=50                   rbdb=50                   rbsb=50
+ ngcon=1                   pketa=0+dpketan_hv25_snw  lketa=0+dlketan_hv25_snw
+ lvth0=0+dlvthn_hv25_snw   pvth0=0+dpvthn_hv25_snw   lk2=0+dlk2n_hv25_snw
+ pk2=0+dpk2n_hv25_snw      lvoff=0+dlvoffn_hv25_snw  pvoff=0+dpvoffn_hv25_snw
+ lu0=0+dlu0n_hv25_snw      pu0=0+dpu0n_hv25_snw      lnfactor=0+dlnfactorn_hv25_snw
+ wnfactor=0+dwnfactorn_hv25_snw                      pnfactor=0+dpnfactorn_hv25_snw
+ lub=0+dlubn_hv25_snw      pub=0+dpubn_hv25_snw      lags=0+dlagsn_hv25_snw
+ pags=0+dpagsn_hv25_snw    lagidl=0+dlagidln_hv25_snw
+ wagidl=0+dwagidln_hv25_snw                          pagidl=0+dpagidln_hv25_snw
+ lkt1=0+dlkt1n_hv25_snw    pkt1=0+dpkt1n_hv25_snw    wat=0+dwatn_hv25_snw
+ lat=0+dlatn_hv25_snw      pat=0+dpatn_hv25_snw      wvsat=0+dwvsatn_hv25_snw
+ minr=1e-3

     11: type=n
+ lmin=1e-006-dxln_hv25_snw lmax=1e-005-dxln_hv25_snw wmin=1e-06
+ wmax=5e-006-dxwn_hv25_snw version=4.5               binunit=2
+ paramchk=1                mobmod=0                  capmod=2
+ igcmod=0                  igbmod=0                  diomod=1
+ rdsmod=1                  rbodymod=0                rgeomod=1
+ rgatemod=1*rgflag_hv25_snw_spw                      permod=1
+ acnqsmod=0                trnqsmod=0                tempmod=0
+ tnom=25                   toxe=toxn_hv25_snw        toxm=5.7e-009
+ dtox=3.1372e-010          epsrox=3.9                wint=0
+ lint=2.23e-007            ll=0                      wl=0
+ lln=1                     wln=1                     lw=0
+ ww=0                      lwn=1                     wwn=1
+ lwl=0                     wwl=0                     llc=0
+ wlc=0                     lwc=0                     wwc=0
+ lwlc=0                    wwlc=0                    xl=2.2e-08+dxln_hv25_snw
+ xw=0+dxwn_hv25_snw        dlc=ddlcn_hv25_snw        dwc=0
+ xpart=1                   toxref=3e-009             dlcig=2.5e-009
+ vth0=0.52834627+dvthn_hv25_snw                      lvth0=1.1176368e-007+dlvthn_hv25_snw
+ wvth0=2.3597776e-009+dwvthn_hv25_snw                pvth0=-2.535033e-014+dpvthn_hv25_snw
+ k1=0.33827                k2=0.13767777+dk2n_hv25_snw
+ lk2=-2.5832218e-012+dlk2n_hv25_snw                  wk2=1.6124216e-009+dwk2n_hv25_snw
+ pk2=7.507584e-019+dpk2n_hv25_snw                    k3=-1.82
+ k3b=1.0692                w0=0                      dvt0=2
+ dvt1=0.0055               dvt2=0.0087               dvt0w=0
+ dvt1w=0                   dvt2w=0                   dsub=0.22592
+ minv=-0.4484              voffl=-5e-009             dvtp0=2.1516e-007
+ dvtp1=0.01                lpe0=5.3147e-007          lpeb=1e-011
+ xj=6.7e-008               ngate=8.5997e+020         ndep=9e+017
+ nsd=1e+020                phin=0.185                cdsc=0
+ cdscb=0                   cdscd=0                   cit=0.0010752888+dcitn_hv25_snw
+ lcit=3.5967456e-014+dlcitn_hv25_snw                 wcit=-3.7545911e-010+dwcitn_hv25_snw
+ pcit=-3.3056352e-020+dpcitn_hv25_snw                voff=-0.12527276+dvoffn_hv25_snw
+ lvoff=-2.4394102e-009+dlvoffn_hv25_snw              wvoff=2.0612392e-009+dwvoffn_hv25_snw
+ pvoff=-2.6213266e-015+dpvoffn_hv25_snw              nfactor=0.6+dnfactorn_hv25_snw
+ eta0=0.01+deta0n_hv25_snw weta0=1e-008+dweta0n_hv25_snw
+ etab=-0.04756895          wetab=1.078275e-008       ud=0
+ lud=0                     wud=0                     pud=0
+ u0=0.040408093+du0n_hv25_snw                        lu0=5.6681055e-009+dlu0n_hv25_snw
+ wu0=-5.2399339e-009+dwu0n_hv25_snw                  pu0=2.2976072e-015+dpu0n_hv25_snw
+ ua=3.7300887e-011+duan_hv25_snw                     lua=-8.4870939e-021+dluan_hv25_snw
+ wua=1.5498942e-017+dwuan_hv25_snw                   pua=1.0119151e-026+dpuan_hv25_snw
+ ub=2.5923422e-018+dubn_hv25_snw                     lub=-1.5697198e-025+dlubn_hv25_snw
+ wub=-9.1961274e-025+dwubn_hv25_snw                  pub=2.7160164e-031+dpubn_hv25_snw
+ uc=1.8100241e-010         luc=9.1316736e-022        wuc=-7.2912394e-017
+ puc=-1.0112256e-027       vsat=140000+dvsatn_hv25_snw
+ a0=-0.0050776696          la0=-3.9393111e-007       wa0=-9.334393e-008
+ pa0=4.6624913e-014        ags=0.94752883+dagsn_hv25_snw
+ lags=-4.5853029e-009+dlagsn_hv25_snw                wags=5.0555807e-008+dwagsn_hv25_snw
+ pags=2.292679e-014+dpagsn_hv25_snw                  a1=0
+ a2=1                      b0=0                      b1=0
+ keta=-0.036396233+dketan_hv25_snw                   lketa=-1.6532006e-013+dlketan_hv25_snw
+ wketa=-7.7877136e-010+dwketan_hv25_snw              pketa=2.0454336e-019+dpketan_hv25_snw
+ dwg=0                     dwb=0                     pclm=0.01
+ pdiblc1=0                 pdiblc2=5e-005            pdiblcb=0
+ drout=0.56                pvag=0.45                 delta=0.01
+ pscbe1=9.264e+008         pscbe2=1e-020             fprout=750
+ pdits=0                   pditsd=0                  pditsl=0
+ rsh=1.750000e+01          rsw=100                   rdw=772
+ prwg=0                    prwb=0                    wr=1
+ alpha0=6.3669e-008        alpha1=1.7728             beta0=28.5
+ agidl=1e-007+dagidln_hv25_snw                       bgidl=4.4810025e+009+dbgidln_hv25_snw
+ lbgidl=-0.0072317952+dlbgidln_hv25_snw              wbgidl=-159.60553+dwbgidln_hv25_snw
+ pbgidl=3.6158976e-008+dpbgidln_hv25_snw             cgidl=21.599
+ egidl=0.55661             aigbacc=0.01238           bigbacc=0.006109
+ cigbacc=0.2809            nigbacc=4.05              aigbinv=0.35
+ bigbinv=0.03              cigbinv=0.006             eigbinv=1.1
+ nigbinv=1                 aigc=0.009898             bigc=0.001383
+ cigc=1.515e-005           aigsd=0.0086              bigsd=0.0004353
+ cigsd=3.925e-020          nigc=1                    poxedge=1
+ pigcd=1.672               ntox=1                    xrcrg1=12
+ xrcrg2=1                  cgso=cgson_hv25_snw       cgdo=cgdon_hv25_snw
+ cgbo=0                    cgdl=cgdln_hv25_snw       cgsl=cgsln_hv25_snw
+ clc=1e-007                cle=0.6                   cf=cfn_hv25_snw
+ ckappas=0.6               ckappad=0.6               acde=0.5
+ moin=5.2                  noff=2.3652               voffcv=-0.27608
+ tvoff=0.001               ltvoff=0                  wtvoff=0
+ ptvoff=0                  kt1=-0.30178598+dkt1n_hv25_snw
+ wkt1=6.9413875e-009+dwkt1n_hv25_snw                 kt1l=0
+ kt2=-0.066333             ute=-1.5                  ua1=2.4526401e-009
+ wua1=-2.84516e-016        ub1=-3.1429185e-018       wub1=3.9092625e-026
+ uc1=2.472e-011            prt=0                     at=-150000+datn_hv25_snw
+ jss=1.850000e-07          jsws=3.310000e-13         jswgs=3.310000e-13
+ njs=1.02                  njd=1.02                  ijthsfwd=0.01
+ ijthdfwd=0.01             ijthsrev=0.01             ijthdrev=0.01
+ bvs=9.300000e+00          xjbvs=1                   xjbvd=1
+ jsd=9.604700e-07          jswd=7.784700e-13         jswgd=7.784700e-13
+ bvd=1.410000e+01          jtsswgs=1e-010+djtsswgsn_hv25_snw
+ jtsswgd=1e-008+djtsswgdn_hv25_snw                   njtsswg=5.8+dnjtsswgn_hv25_snw
+ xtsswgs=0.1               xtsswgd=0.36533           tnjtsswg=1
+ vtsswgs=1                 vtsswgd=1                 pbs=7.800000e-01
+ cjs=cjsn_hv25_snw         mjs=2.900000e-01          pbsws=5.200000e-01
+ cjsws=cjswsn_hv25_snw     mjsws=9.300000e-02        pbswgs=5.500000e-01
+ cjswgs=cjswgsn_hv25_snw   mjswgs=2.200000e-01       pbd=6.000000e-01
+ cjd=cjdn_hv25_snw         mjd=3.600000e-01          pbswd=6.500000e-01
+ cjswd=cjswdn_hv25_snw     mjswd=2.800000e-01        pbswgd=7.000000e-01
+ cjswgd=cjswgdn_hv25_snw   mjswgd=3.300000e-01       tpb=2.200000e-03
+ tcj=2.000000e-03          tpbsw=2.000000e-03        tcjsw=1.160000e-03
+ tpbswg=2.500000e-03       tcjswg=1.640000e-03       xtis=3
+ xtid=3                    dmcg=5.800000e-08         dmci=5.800000e-08
+ dmdg=0                    dmcgt=0                   dwj=0
+ xgw=0                     xgl=-1.090000e-08         rshg=1.560000e+01
+ gbmin=1e-012              rbpb=50                   rbpd=50
+ rbps=50                   rbdb=50                   rbsb=50
+ ngcon=1                   lnfactor=0+dlnfactorn_hv25_snw
+ wnfactor=0+dwnfactorn_hv25_snw                      pnfactor=0+dpnfactorn_hv25_snw
+ lagidl=0+dlagidln_hv25_snw                          wagidl=0+dwagidln_hv25_snw
+ pagidl=0+dpagidln_hv25_snw                          lkt1=0+dlkt1n_hv25_snw
+ pkt1=0+dpkt1n_hv25_snw    wat=0+dwatn_hv25_snw      lat=0+dlatn_hv25_snw
+ pat=0+dpatn_hv25_snw      wvsat=0+dwvsatn_hv25_snw  minr=1e-3

     12: type=n
+ lmin=7.92e-07             lmax=1e-006-dxln_hv25_snw wmin=1e-06
+ wmax=5e-006-dxwn_hv25_snw version=4.5               binunit=2
+ paramchk=1                mobmod=0                  capmod=2
+ igcmod=0                  igbmod=0                  diomod=1
+ rdsmod=1                  rbodymod=0                rgeomod=1
+ rgatemod=1*rgflag_hv25_snw_spw                      permod=1
+ acnqsmod=0                trnqsmod=0                tempmod=0
+ tnom=25                   toxe=toxn_hv25_snw        toxm=5.7e-009
+ dtox=3.1372e-010          epsrox=3.9                wint=0
+ lint=2.23e-007            ll=0                      wl=0
+ lln=1                     wln=1                     lw=0
+ ww=0                      lwn=1                     wwn=1
+ lwl=0                     wwl=0                     llc=0
+ wlc=0                     lwc=0                     wwc=0
+ lwlc=0                    wwlc=0                    xl=2.2e-08+dxln_hv25_snw
+ xw=0+dxwn_hv25_snw        dlc=ddlcn_hv25_snw        dwc=0
+ xpart=1                   toxref=3e-009             dlcig=2.5e-009
+ vth0=0.78039805+dvthn_hv25_snw                      lvth0=-3.3418145e-008+dlvthn_hv25_snw
+ wvth0=-1.0115549e-007+dwvthn_hv25_snw               pvth0=3.4274465e-014+dpvthn_hv25_snw
+ k1=0.33827                k2=0.13116056+dk2n_hv25_snw
+ lk2=3.7513291e-009+dlk2n_hv25_snw                   wk2=1.1204028e-008+dwk2n_hv25_snw
+ pk2=-5.5240145e-015+dpk2n_hv25_snw                  k3=-1.82
+ k3b=1.0692                w0=0                      dvt0=2
+ dvt1=0.0055               dvt2=0.0087               dvt0w=0
+ dvt1w=0                   dvt2w=0                   dsub=0.22592
+ minv=-0.4484              voffl=-5e-009             dvtp0=2.1516e-007
+ dvtp1=0.01                lpe0=5.3147e-007          lpeb=1e-011
+ xj=6.7e-008               ngate=8.5997e+020         ndep=9e+017
+ nsd=1e+020                phin=0.185                cdsc=0
+ cdscb=0                   cdscd=0                   cit=0.0027210115+dcitn_hv25_snw
+ lcit=-9.4790031e-010+dlcitn_hv25_snw                wcit=-1.0814875e-009+dwcitn_hv25_snw
+ pcit=4.0663931e-016+dpcitn_hv25_snw                 voff=-0.15537259+dvoffn_hv25_snw
+ lvoff=1.4898095e-008+dlvoffn_hv25_snw               wvoff=-1.4220264e-008+dwvoffn_hv25_snw
+ pvoff=6.7568193e-015+dpvoffn_hv25_snw               nfactor=0.6+dnfactorn_hv25_snw
+ eta0=-0.0088+deta0n_hv25_snw                        leta0=1.08288e-008
+ weta0=2.88e-008+dweta0n_hv25_snw                    peta0=-1.08288e-014
+ etab=-0.04756895          wetab=1.078275e-008       ud=0
+ lud=0                     wud=0                     pud=0
+ u0=0.042255834+du0n_hv25_snw                        lu0=4.6038064e-009+dlu0n_hv25_snw
+ wu0=1.0970264e-009+dwu0n_hv25_snw                   pu0=-1.3524819e-015+dpu0n_hv25_snw
+ ua=-7.5423872e-010+duan_hv25_snw                    lua=4.5591833e-016+dluan_hv25_snw
+ wua=2.0683757e-016+dwuan_hv25_snw                   pua=-1.1020093e-022+dpuan_hv25_snw
+ ub=2.3282748e-018+dubn_hv25_snw                     lub=-4.8691428e-027+dlubn_hv25_snw
+ wub=1.5359801e-025+dwubn_hv25_snw                   pub=-3.4656776e-031+dpubn_hv25_snw
+ uc=3.6791126e-010         luc=-1.0765858e-016       wuc=-5.3618161e-018
+ puc=-3.8910144e-023       vsat=140000+dvsatn_hv25_snw
+ a0=-0.28452425            la0=-2.3296988e-007       wa0=1.1193191e-006
+ pa0=-6.5186896e-013       ags=-0.10826248+dagsn_hv25_snw
+ lags=6.0355049e-007+dlagsn_hv25_snw                 wags=5.4528968e-007+dwagsn_hv25_snw
+ pags=-2.6203992e-013+dpagsn_hv25_snw                a1=0
+ a2=1                      b0=0                      b1=0
+ keta=-0.10089668+dketan_hv25_snw                    lketa=3.7152091e-008+dlketan_hv25_snw
+ wketa=-1.7351626e-008+dwketan_hv25_snw              pketa=9.5461688e-015+dpketan_hv25_snw
+ dwg=0                     dwb=0                     pclm=-0.084
+ lpclm=5.4144e-008         pdiblc1=0                 pdiblc2=-0.001172
+ lpdiblc2=7.03872e-010     pdiblcb=0                 drout=0.56
+ pvag=0.45                 delta=0.01                pscbe1=9.264e+008
+ pscbe2=1e-020             fprout=750                pdits=0
+ pditsd=0                  pditsl=0                  rsh=1.750000e+01
+ rsw=100                   rdw=772                   prwg=0
+ prwb=0                    wr=1                      alpha0=6.3669e-008
+ alpha1=1.7728             beta0=28.5                agidl=1e-007+dagidln_hv25_snw
+ bgidl=4.280187e+009+dbgidln_hv25_snw                lbgidl=115.66252+dlbgidln_hv25_snw
+ wbgidl=433.51735+dwbgidln_hv25_snw                  pbgidl=-0.00034160262+dpbgidln_hv25_snw
+ cgidl=21.599              egidl=0.55661             aigbacc=0.01238
+ bigbacc=0.006109          cigbacc=0.2809            nigbacc=4.05
+ aigbinv=0.35              bigbinv=0.03              cigbinv=0.006
+ eigbinv=1.1               nigbinv=1                 aigc=0.009898
+ bigc=0.001383             cigc=1.515e-005           aigsd=0.0086
+ bigsd=0.0004353           cigsd=3.925e-020          nigc=1
+ poxedge=1                 pigcd=1.672               ntox=1
+ xrcrg1=12                 xrcrg2=1                  cgso=cgson_hv25_snw
+ cgdo=cgdon_hv25_snw       cgbo=0                    cgdl=cgdln_hv25_snw
+ cgsl=cgsln_hv25_snw       clc=1e-007                cle=0.6
+ cf=cfn_hv25_snw           ckappas=0.6               ckappad=0.6
+ acde=0.5                  moin=5.2                  noff=2.3652
+ voffcv=-0.27608           tvoff=0.001               ltvoff=0
+ wtvoff=0                  ptvoff=0                  kt1=-0.31528152+dkt1n_hv25_snw
+ lkt1=7.7734297e-009+dlkt1n_hv25_snw                 wkt1=-3.955304e-009+dwkt1n_hv25_snw
+ pkt1=6.2764943e-015+dpkt1n_hv25_snw                 kt1l=0
+ kt2=-0.066333             ute=-1.5                  ua1=2.4865555e-009
+ lua1=-1.9535264e-017      wua1=-4.4998608e-016      pua1=9.5310766e-023
+ ub1=-3.0276154e-018       lub1=-6.6414628e-026      wub1=-5.3742324e-025
+ pub1=3.3207314e-031       uc1=2.472e-011            prt=0
+ at=-152350+datn_hv25_snw  lat=0.0013536+dlatn_hv25_snw
+ wat=0.01175+dwatn_hv25_snw                          pat=-6.768e-009+dpatn_hv25_snw
+ jss=1.850000e-07          jsws=3.310000e-13         jswgs=3.310000e-13
+ njs=1.02                  njd=1.02                  ijthsfwd=0.01
+ ijthdfwd=0.01             ijthsrev=0.01             ijthdrev=0.01
+ bvs=9.300000e+00          xjbvs=1                   xjbvd=1
+ jsd=9.604700e-07          jswd=7.784700e-13         jswgd=7.784700e-13
+ bvd=1.410000e+01          jtsswgs=1e-010+djtsswgsn_hv25_snw
+ jtsswgd=1e-008+djtsswgdn_hv25_snw                   njtsswg=5.8+dnjtsswgn_hv25_snw
+ xtsswgs=0.1               xtsswgd=0.36533           tnjtsswg=1
+ vtsswgs=1                 vtsswgd=1                 pbs=7.800000e-01
+ cjs=cjsn_hv25_snw         mjs=2.900000e-01          pbsws=5.200000e-01
+ cjsws=cjswsn_hv25_snw     mjsws=9.300000e-02        pbswgs=5.500000e-01
+ cjswgs=cjswgsn_hv25_snw   mjswgs=2.200000e-01       pbd=6.000000e-01
+ cjd=cjdn_hv25_snw         mjd=3.600000e-01          pbswd=6.500000e-01
+ cjswd=cjswdn_hv25_snw     mjswd=2.800000e-01        pbswgd=7.000000e-01
+ cjswgd=cjswgdn_hv25_snw   mjswgd=3.300000e-01       tpb=2.200000e-03
+ tcj=2.000000e-03          tpbsw=2.000000e-03        tcjsw=1.160000e-03
+ tpbswg=2.500000e-03       tcjswg=1.640000e-03       xtis=3
+ xtid=3                    dmcg=5.800000e-08         dmci=5.800000e-08
+ dmdg=0                    dmcgt=0                   dwj=0
+ xgw=0                     xgl=-1.090000e-08         rshg=1.560000e+01
+ gbmin=1e-012              rbpb=50                   rbpd=50
+ rbps=50                   rbdb=50                   rbsb=50
+ ngcon=1                   lnfactor=0+dlnfactorn_hv25_snw
+ wnfactor=0+dwnfactorn_hv25_snw                      pnfactor=0+dpnfactorn_hv25_snw
+ lagidl=0+dlagidln_hv25_snw                          wagidl=0+dwagidln_hv25_snw
+ pagidl=0+dpagidln_hv25_snw                          wvsat=0+dwvsatn_hv25_snw
+ minr=1e-3

// *********************************************************************************************
//
//                   *
//                                 2.5V PMOS HVMOS DEVICE MODELS
//                     *
//
//                   *
// *********************************************************************************************

     }
model pch_hv25_spw bsim4  {
     1: type=p
+ lmin=1e-005-dxlp_hv25_spw lmax=0.000900001          wmin=2e-005-dxwp_hv25_spw
+ wmax=0.000900001          version=4.5               binunit=2
+ paramchk=1                mobmod=0                  capmod=2
+ igcmod=0                  igbmod=0                  diomod=1
+ rdsmod=1                  rbodymod=0                rgeomod=1
+ rgatemod=1*rgflag_hv25_snw_spw                      permod=1
+ acnqsmod=0                trnqsmod=0                tempmod=0
+ tnom=25                   toxe=toxp_hv25_spw        toxm=6.13e-009
+ dtox=3.9839e-010          epsrox=3.9                wint=0
+ lint=1.61e-007            ll=0                      wl=0
+ lln=1                     wln=1                     lw=0
+ ww=0                      lwn=1                     wwn=1
+ lwl=0                     wwl=0                     llc=0
+ wlc=0                     lwc=0                     wwc=0
+ lwlc=0                    wwlc=0                    xl=2.2e-08+dxlp_hv25_spw
+ xw=0+dxwp_hv25_spw        dlc=ddlcp_hv25_spw        dwc=0
+ xpart=1                   toxref=3e-009             dlcig=2.5e-009
+ vth0=-0.76456+dvthp_hv25_spw                        lvth0=2.2285703e-015+dlvthp_hv25_spw
+ wvth0=2.229312e-015+dwvthp_hv25_spw                 pvth0=-2.0057151e-018+dpvthp_hv25_spw
+ k1=0.52871                k2=0.053099               k3=-2.3465
+ k3b=1                     w0=0                      dvt0=0.85946
+ dvt1=0.034455             dvt2=0                    dvt0w=0
+ dvt1w=0                   dvt2w=0                   dsub=0.33
+ minv=-0.29912             voffl=-5e-009             dvtp0=3e-007
+ dvtp1=0.1                 lpe0=6.3e-008             lpeb=3.1121e-009
+ xj=8.5e-008               ngate=2.092e+020          ndep=6e+017
+ nsd=1e+020                phin=0.174                cdsc=0
+ cdscb=0                   cdscd=0                   cit=0.0008+dcitp_hv25_spw
+ voff=-0.135+dvoffp_hv25_spw                         nfactor=0.7+dnfactorp_hv25_spw
+ eta0=0.05+deta0p_hv25_spw etab=-0.0847              ud=0
+ lud=0                     wud=0                     pud=0
+ u0=0.012+du0p_hv25_spw    ua=1.5641e-009            lua=-2.2285699e-023
+ wua=-2.2293132e-023       pua=2.0057152e-026        ub=8.6738e-020
+ lub=-8.9142793e-034       wub=-8.9172527e-034       pub=8.0228608e-037
+ uc=-1.6e-011              vsat=90000+dvsatp_hv25_spw
+ a0=-0.15281+da0p_hv25_spw ags=3.7754+dagsp_hv25_spw a1=0
+ a2=1                      b0=0                      b1=0
+ keta=-0.061176            dwg=0                     dwb=0
+ pclm=0.05                 pdiblc1=0                 pdiblc2=0.0001
+ pdiblcb=0                 drout=0.56                pvag=0
+ delta=0.01                pscbe1=9.264e+008         pscbe2=1e-020
+ fprout=100                pdits=0                   pditsd=0
+ rsh=1.520000e+01          rsw=100                   rdw=2088
+ prwg=0                    prwb=0                    wr=1
+ alpha0=1.1625e-008        alpha1=0.040625           beta0=28.8
+ agidl=5e-008+dagidlp_hv25_spw                       bgidl=4.4244e+009+dbgidlp_hv25_spw
+ cgidl=10                  egidl=0.902               aigbacc=0.01238
+ bigbacc=0.006109          cigbacc=0.2809            nigbacc=4.05
+ aigbinv=0.35              bigbinv=0.03              cigbinv=0.006
+ eigbinv=1.1               nigbinv=1                 aigc=0.009898
+ bigc=0.001383             cigc=1.515e-005           aigsd=0.0086
+ bigsd=0.0004353           cigsd=3.925e-020          nigc=1
+ poxedge=1                 pigcd=1.672               ntox=1
+ xrcrg1=12                 xrcrg2=1                  cgso=cgsop_hv25_spw
+ cgdo=cgdop_hv25_spw       cgbo=0                    cgdl=cgdlp_hv25_spw
+ cgsl=cgslp_hv25_spw       clc=1e-007                cle=0.6
+ cf=cfp_hv25_spw           ckappas=0.6               ckappad=0.6
+ acde=0.7                  moin=6.4033               noff=1.7249
+ voffcv=-0.058992          tvoff=0.001               ltvoff=0
+ wtvoff=0                  ptvoff=0                  kt1=-0.35191+dkt1p_hv25_spw
+ kt1l=0                    kt2=-0.074983             ute=-1.5
+ ua1=-1.1323e-009          ub1=7.6211e-019           uc1=3.8065e-011
+ prt=0                     at=-120000+datp_hv25_spw  jss=1.540000e-07
+ jsws=4.710000e-13         jswgs=4.710000e-13        njs=1.02
+ njd=1.02                  ijthsfwd=0.01             ijthdfwd=0.01
+ ijthsrev=0.01             ijthdrev=0.01             bvs=8.700000e+00
+ xjbvs=1                   xjbvd=1                   jsd=1.012800e-07
+ jswd=3.752600e-13         jswgd=3.752600e-13        bvd=1.430000e+01
+ jtsswgs=1e-010+djtsswgsp_hv25_spw                   jtsswgd=5.3e-009+djtsswgdp_hv25_spw
+ njtsswg=9+dnjtsswgp_hv25_spw                        xtsswgs=0.1
+ xtsswgd=0.43              tnjtsswg=1                vtsswgs=1
+ vtsswgd=1                 pbs=8.000000e-01          cjs=cjsp_hv25_spw
+ mjs=3.400000e-01          pbsws=4.500000e-01        cjsws=cjswsp_hv25_spw
+ mjsws=1.480000e-01        pbswgs=5.500000e-01       cjswgs=cjswgsp_hv25_spw
+ mjswgs=4.500000e-01       pbd=6.600000e-01          cjd=cjdp_hv25_spw
+ mjd=3.300000e-01          pbswd=6.500000e-01        cjswd=cjswdp_hv25_spw
+ mjswd=3.400000e-01        pbswgd=7.000000e-01       cjswgd=cjswgdp_hv25_spw
+ mjswgd=4.000000e-01       tpb=1.550000e-03          tcj=1.100000e-03
+ tpbsw=1.550000e-03        tcjsw=1.100000e-03        tpbswg=1.500000e-03
+ tcjswg=1.170000e-03       xtis=3                    xtid=3
+ dmcg=5.800000e-08         dmci=5.800000e-08         dmdg=0
+ dmcgt=0                   dwj=0                     xgw=0
+ xgl=-8.200000e-09         rshg=1.410000e+01         gbmin=1e-012
+ rbpb=50                   rbpd=50                   rbps=50
+ rbdb=50                   rbsb=50                   ngcon=1
+ lcit=0+dlcitp_hv25_spw    wcit=0+dwcitp_hv25_spw    pcit=0+dpcitp_hv25_spw
+ lu0=0+dlu0p_hv25_spw      wu0=0+dwu0p_hv25_spw      pu0=0+dpu0p_hv25_spw
+ la0=0+dla0p_hv25_spw      wa0=0+dwa0p_hv25_spw      pa0=0+dpa0p_hv25_spw
+ lags=0+dlagsp_hv25_spw    wags=0+dwagsp_hv25_spw    pags=0+dpagsp_hv25_spw
+ lvsat=0+dlvsatp_hv25_spw  wnfactor=0+dwnfactorp_hv25_spw
+ lnfactor=0+dlnfactorp_hv25_spw                      pnfactor=0+dpnfactorp_hv25_spw
+ pvsat=0+dpvsatp_hv25_spw  wvsat=0+dwvsatp_hv25_spw  lvoff=0+dlvoffp_hv25_spw
+ wvoff=0+dwvoffp_hv25_spw  pvoff=0+dpvoffp_hv25_spw  lkt1=0+dlkt1p_hv25_spw
+ wkt1=0+dwkt1p_hv25_spw    pkt1=0+dpkt1p_hv25_spw    lat=0+dlatp_hv25_spw
+ wat=0+dwatp_hv25_spw      pat=0+dpatp_hv25_spw      lagidl=0+dlagidlp_hv25_spw
+ wagidl=0+dwagidlp_hv25_spw                          pagidl=0+dpagidlp_hv25_spw
+ lbgidl=0+dlbgidlp_hv25_spw                          wbgidl=0+dwbgidlp_hv25_spw
+ pbgidl=0+dpbgidlp_hv25_spw                          minr=1e-3

     2: type=p
+ lmin=9e-007-dxlp_hv25_spw lmax=1e-005-dxlp_hv25_spw wmin=2e-005-dxwp_hv25_spw
+ wmax=0.000900001          version=4.5               binunit=2
+ paramchk=1                mobmod=0                  capmod=2
+ igcmod=0                  igbmod=0                  diomod=1
+ rdsmod=1                  rbodymod=0                rgeomod=1
+ rgatemod=1*rgflag_hv25_snw_spw                      permod=1
+ acnqsmod=0                trnqsmod=0                tempmod=0
+ tnom=25                   toxe=toxp_hv25_spw        toxm=6.13e-009
+ dtox=3.9839e-010          epsrox=3.9                wint=0
+ lint=1.61e-007            ll=0                      wl=0
+ lln=1                     wln=1                     lw=0
+ ww=0                      lwn=1                     wwn=1
+ lwl=0                     wwl=0                     llc=0
+ wlc=0                     lwc=0                     wwc=0
+ lwlc=0                    wwlc=0                    xl=2.2e-08+dxlp_hv25_spw
+ xw=0+dxwp_hv25_spw        dlc=ddlcp_hv25_spw        dwc=0
+ xpart=1                   toxref=3e-009             dlcig=2.5e-009
+ vth0=-0.77311165+dvthp_hv25_spw                     lvth0=8.2950989e-008+dlvthp_hv25_spw
+ wvth0=-2.1803197e-013+dwvthp_hv25_spw               pvth0=1.3081918e-019+dpvthp_hv25_spw
+ k1=0.52871                k2=0.053099               k3=-2.3465
+ k3b=1                     w0=0                      dvt0=0.85946
+ dvt1=0.034455             dvt2=0                    dvt0w=0
+ dvt1w=0                   dvt2w=0                   dsub=0.33
+ minv=-0.29912             voffl=-5e-009             dvtp0=3e-007
+ dvtp1=0.1                 lpe0=6.3e-008             lpeb=3.1121e-009
+ xj=8.5e-008               ngate=2.092e+020          ndep=6e+017
+ nsd=1e+020                phin=0.174                cdsc=0
+ cdscb=0                   cdscd=0                   cit=0.0008+dcitp_hv25_spw
+ voff=-0.13678022+dvoffp_hv25_spw                    lvoff=1.7268132e-008+dlvoffp_hv25_spw
+ nfactor=0.7+dnfactorp_hv25_spw                      eta0=0.05+deta0p_hv25_spw
+ etab=-0.0847              ud=0                      lud=0
+ wud=0                     pud=0                     u0=0.012+du0p_hv25_spw
+ ua=1.5947857e-009         lua=-2.9765143e-016       wua=2.1803196e-021
+ pua=-1.3081918e-027       ub=8.3909956e-020         lub=2.7432026e-026
+ wub=8.7212785e-032        pub=-5.2327671e-038       uc=-1.6e-011
+ vsat=90000+dvsatp_hv25_spw                          a0=-0.15958868+da0p_hv25_spw
+ la0=6.5753209e-008+dla0p_hv25_spw                   ags=3.7907297+dagsp_hv25_spw
+ lags=-1.486978e-007+dlagsp_hv25_spw                 a1=0
+ a2=1                      b0=0                      b1=0
+ keta=-0.061176            dwg=0                     dwb=0
+ pclm=0.043406593          lpclm=6.3956044e-008      pdiblc1=0
+ pdiblc2=0.0001            pdiblcb=0                 drout=0.56
+ pvag=0                    delta=0.01                pscbe1=9.264e+008
+ pscbe2=1e-020             fprout=100                pdits=0
+ pditsd=0                  rsh=1.520000e+01          rsw=100
+ rdw=2088                  prwg=0                    prwb=0
+ wr=1                      alpha0=1.1625e-008        alpha1=0.040625
+ beta0=28.8                agidl=5e-008+dagidlp_hv25_spw
+ bgidl=4.4244e+009+dbgidlp_hv25_spw                  cgidl=10
+ egidl=0.902               aigbacc=0.01238           bigbacc=0.006109
+ cigbacc=0.2809            nigbacc=4.05              aigbinv=0.35
+ bigbinv=0.03              cigbinv=0.006             eigbinv=1.1
+ nigbinv=1                 aigc=0.009898             bigc=0.001383
+ cigc=1.515e-005           aigsd=0.0086              bigsd=0.0004353
+ cigsd=3.925e-020          nigc=1                    poxedge=1
+ pigcd=1.672               ntox=1                    xrcrg1=12
+ xrcrg2=1                  cgso=cgsop_hv25_spw       cgdo=cgdop_hv25_spw
+ cgbo=0                    cgdl=cgdlp_hv25_spw       cgsl=cgslp_hv25_spw
+ clc=1e-007                cle=0.6                   cf=cfp_hv25_spw
+ ckappas=0.6               ckappad=0.6               acde=0.7
+ moin=6.4033               noff=1.7249               voffcv=-0.058992
+ tvoff=0.001               ltvoff=0                  wtvoff=0
+ ptvoff=0                  kt1=-0.35191+dkt1p_hv25_spw
+ kt1l=0                    kt2=-0.074983             ute=-1.5
+ ua1=-1.1323e-009          ub1=7.6211e-019           uc1=3.8065e-011
+ prt=0                     at=-120000+datp_hv25_spw  jss=1.540000e-07
+ jsws=4.710000e-13         jswgs=4.710000e-13        njs=1.02
+ njd=1.02                  ijthsfwd=0.01             ijthdfwd=0.01
+ ijthsrev=0.01             ijthdrev=0.01             bvs=8.700000e+00
+ xjbvs=1                   xjbvd=1                   jsd=1.012800e-07
+ jswd=3.752600e-13         jswgd=3.752600e-13        bvd=1.430000e+01
+ jtsswgs=1e-010+djtsswgsp_hv25_spw                   jtsswgd=5.3e-009+djtsswgdp_hv25_spw
+ njtsswg=9+dnjtsswgp_hv25_spw                        xtsswgs=0.1
+ xtsswgd=0.43              tnjtsswg=1                vtsswgs=1
+ vtsswgd=1                 pbs=8.000000e-01          cjs=cjsp_hv25_spw
+ mjs=3.400000e-01          pbsws=4.500000e-01        cjsws=cjswsp_hv25_spw
+ mjsws=1.480000e-01        pbswgs=5.500000e-01       cjswgs=cjswgsp_hv25_spw
+ mjswgs=4.500000e-01       pbd=6.600000e-01          cjd=cjdp_hv25_spw
+ mjd=3.300000e-01          pbswd=6.500000e-01        cjswd=cjswdp_hv25_spw
+ mjswd=3.400000e-01        pbswgd=7.000000e-01       cjswgd=cjswgdp_hv25_spw
+ mjswgd=4.000000e-01       tpb=1.550000e-03          tcj=1.100000e-03
+ tpbsw=1.550000e-03        tcjsw=1.100000e-03        tpbswg=1.500000e-03
+ tcjswg=1.170000e-03       xtis=3                    xtid=3
+ dmcg=5.800000e-08         dmci=5.800000e-08         dmdg=0
+ dmcgt=0                   dwj=0                     xgw=0
+ xgl=-8.200000e-09         rshg=1.410000e+01         gbmin=1e-012
+ rbpb=50                   rbpd=50                   rbps=50
+ rbdb=50                   rbsb=50                   ngcon=1
+ lcit=0+dlcitp_hv25_spw    wcit=0+dwcitp_hv25_spw    pcit=0+dpcitp_hv25_spw
+ lu0=0+dlu0p_hv25_spw      wu0=0+dwu0p_hv25_spw      pu0=0+dpu0p_hv25_spw
+ wa0=0+dwa0p_hv25_spw      pa0=0+dpa0p_hv25_spw      wags=0+dwagsp_hv25_spw
+ pags=0+dpagsp_hv25_spw    lvsat=0+dlvsatp_hv25_spw  wnfactor=0+dwnfactorp_hv25_spw
+ lnfactor=0+dlnfactorp_hv25_spw                      pnfactor=0+dpnfactorp_hv25_spw
+ pvsat=0+dpvsatp_hv25_spw  wvsat=0+dwvsatp_hv25_spw  wvoff=0+dwvoffp_hv25_spw
+ pvoff=0+dpvoffp_hv25_spw  lkt1=0+dlkt1p_hv25_spw    wkt1=0+dwkt1p_hv25_spw
+ pkt1=0+dpkt1p_hv25_spw    lat=0+dlatp_hv25_spw      wat=0+dwatp_hv25_spw
+ pat=0+dpatp_hv25_spw      lagidl=0+dlagidlp_hv25_spw
+ wagidl=0+dwagidlp_hv25_spw                          pagidl=0+dpagidlp_hv25_spw
+ lbgidl=0+dlbgidlp_hv25_spw                          wbgidl=0+dwbgidlp_hv25_spw
+ pbgidl=0+dpbgidlp_hv25_spw                          minr=1e-3

     3: type=p
+ lmin=5.94e-07             lmax=9e-007-dxlp_hv25_spw wmin=2e-005-dxwp_hv25_spw
+ wmax=0.000900001          version=4.5               binunit=2
+ paramchk=1                mobmod=0                  capmod=2
+ igcmod=0                  igbmod=0                  diomod=1
+ rdsmod=1                  rbodymod=0                rgeomod=1
+ rgatemod=1*rgflag_hv25_snw_spw                      permod=1
+ acnqsmod=0                trnqsmod=0                tempmod=0
+ tnom=25                   toxe=toxp_hv25_spw        toxm=6.13e-009
+ dtox=3.9839e-010          epsrox=3.9                wint=0
+ lint=1.61e-007            ll=0                      wl=0
+ lln=1                     wln=1                     lw=0
+ ww=0                      lwn=1                     wwn=1
+ lwl=0                     wwl=0                     llc=0
+ wlc=0                     lwc=0                     wwc=0
+ lwlc=0                    wwlc=0                    xl=2.2e-08+dxlp_hv25_spw
+ xw=0+dxwp_hv25_spw        dlc=ddlcp_hv25_spw        dwc=0
+ xpart=1                   toxref=3e-009             dlcig=2.5e-009
+ vth0=-0.63301+dvthp_hv25_spw                        lvth0=-1.11e-009+dlvthp_hv25_spw
+ k1=0.52871                k2=0.076499               lk2=-1.404e-008
+ k3=-2.3465                k3b=1                     w0=0
+ dvt0=0.85946              dvt1=0.034455             dvt2=0
+ dvt0w=0                   dvt1w=0                   dvt2w=0
+ dsub=0.33                 minv=-0.29912             voffl=-5e-009
+ dvtp0=3e-007              dvtp1=0.1                 lpe0=6.3e-008
+ lpeb=3.1121e-009          xj=8.5e-008               ngate=2.092e+020
+ ndep=6e+017               nsd=1e+020                phin=0.174
+ cdsc=0                    cdscb=0                   cdscd=0
+ cit=0.0007+dcitp_hv25_spw lcit=6e-011+dlcitp_hv25_spw
+ voff=-0.121+dvoffp_hv25_spw                         lvoff=7.8e-009+dlvoffp_hv25_spw
+ nfactor=0.7+dnfactorp_hv25_spw                      eta0=0.03+deta0p_hv25_spw
+ leta0=1.2e-008            etab=-0.0847              ud=0
+ lud=0                     wud=0                     pud=0
+ u0=0.006+du0p_hv25_spw    lu0=3.6e-009+dlu0p_hv25_spw
+ ua=-7.615e-010            lua=1.11612e-015          ub=1.18487e-018
+ lub=-6.33144e-025         uc=6.2499e-011            luc=-4.70994e-017
+ vsat=90000+dvsatp_hv25_spw                          a0=0.3+da0p_hv25_spw
+ la0=-2.1e-007+dla0p_hv25_spw                        ags=5.6008+dagsp_hv25_spw
+ lags=-1.23474e-006+dlagsp_hv25_spw                  a1=0
+ a2=1                      b0=0                      b1=0
+ keta=-0.061176            dwg=0                     dwb=0
+ pclm=-0.1                 lpclm=1.5e-007            pdiblc1=0
+ pdiblc2=0.0001            pdiblcb=0                 drout=0.56
+ pvag=0                    delta=0.01                pscbe1=9.264e+008
+ pscbe2=1e-020             fprout=100                pdits=0
+ pditsd=0                  rsh=1.520000e+01          rsw=100
+ rdw=2088                  prwg=0                    prwb=0
+ wr=1                      alpha0=1.1625e-008        alpha1=0.040625
+ beta0=28.8                agidl=5e-008+dagidlp_hv25_spw
+ bgidl=4.2912e+009+dbgidlp_hv25_spw                  lbgidl=79.92+dlbgidlp_hv25_spw
+ cgidl=10                  egidl=0.902               aigbacc=0.01238
+ bigbacc=0.006109          cigbacc=0.2809            nigbacc=4.05
+ aigbinv=0.35              bigbinv=0.03              cigbinv=0.006
+ eigbinv=1.1               nigbinv=1                 aigc=0.009898
+ bigc=0.001383             cigc=1.515e-005           aigsd=0.0086
+ bigsd=0.0004353           cigsd=3.925e-020          nigc=1
+ poxedge=1                 pigcd=1.672               ntox=1
+ xrcrg1=12                 xrcrg2=1                  cgso=cgsop_hv25_spw
+ cgdo=cgdop_hv25_spw       cgbo=0                    cgdl=cgdlp_hv25_spw
+ cgsl=cgslp_hv25_spw       clc=1e-007                cle=0.6
+ cf=cfp_hv25_spw           ckappas=0.6               ckappad=0.6
+ acde=0.7                  moin=6.4033               noff=1.7249
+ voffcv=-0.058992          tvoff=0.001               ltvoff=0
+ wtvoff=0                  ptvoff=0                  kt1=-0.33747+dkt1p_hv25_spw
+ lkt1=-8.664e-009+dlkt1p_hv25_spw                    kt1l=0
+ kt2=-0.095978             lkt2=1.2597e-008          ute=-1.5
+ ua1=-1.51744e-009         lua1=2.31084e-016         ub1=1.41809e-018
+ lub1=-3.93588e-025        uc1=3.8065e-011           prt=0
+ at=-120000+datp_hv25_spw  jss=1.540000e-07          jsws=4.710000e-13
+ jswgs=4.710000e-13        njs=1.02                  njd=1.02
+ ijthsfwd=0.01             ijthdfwd=0.01             ijthsrev=0.01
+ ijthdrev=0.01             bvs=8.700000e+00          xjbvs=1
+ xjbvd=1                   jsd=1.012800e-07          jswd=3.752600e-13
+ jswgd=3.752600e-13        bvd=1.430000e+01          jtsswgs=1e-010+djtsswgsp_hv25_spw
+ jtsswgd=5.3e-009+djtsswgdp_hv25_spw                 njtsswg=9+dnjtsswgp_hv25_spw
+ xtsswgs=0.1               xtsswgd=0.43              tnjtsswg=1
+ vtsswgs=1                 vtsswgd=1                 pbs=8.000000e-01
+ cjs=cjsp_hv25_spw         mjs=3.400000e-01          pbsws=4.500000e-01
+ cjsws=cjswsp_hv25_spw     mjsws=1.480000e-01        pbswgs=5.500000e-01
+ cjswgs=cjswgsp_hv25_spw   mjswgs=4.500000e-01       pbd=6.600000e-01
+ cjd=cjdp_hv25_spw         mjd=3.300000e-01          pbswd=6.500000e-01
+ cjswd=cjswdp_hv25_spw     mjswd=3.400000e-01        pbswgd=7.000000e-01
+ cjswgd=cjswgdp_hv25_spw   mjswgd=4.000000e-01       tpb=1.550000e-03
+ tcj=1.100000e-03          tpbsw=1.550000e-03        tcjsw=1.100000e-03
+ tpbswg=1.500000e-03       tcjswg=1.170000e-03       xtis=3
+ xtid=3                    dmcg=5.800000e-08         dmci=5.800000e-08
+ dmdg=0                    dmcgt=0                   dwj=0
+ xgw=0                     xgl=-8.200000e-09         rshg=1.410000e+01
+ gbmin=1e-012              rbpb=50                   rbpd=50
+ rbps=50                   rbdb=50                   rbsb=50
+ ngcon=1                   wvth0=0+dwvthp_hv25_spw   pvth0=0+dpvthp_hv25_spw
+ wcit=0+dwcitp_hv25_spw    pcit=0+dpcitp_hv25_spw    wu0=0+dwu0p_hv25_spw
+ pu0=0+dpu0p_hv25_spw      wa0=0+dwa0p_hv25_spw      pa0=0+dpa0p_hv25_spw
+ wags=0+dwagsp_hv25_spw    pags=0+dpagsp_hv25_spw    lvsat=0+dlvsatp_hv25_spw
+ wnfactor=0+dwnfactorp_hv25_spw                      lnfactor=0+dlnfactorp_hv25_spw
+ pnfactor=0+dpnfactorp_hv25_spw                      pvsat=0+dpvsatp_hv25_spw
+ wvsat=0+dwvsatp_hv25_spw  wvoff=0+dwvoffp_hv25_spw  pvoff=0+dpvoffp_hv25_spw
+ wkt1=0+dwkt1p_hv25_spw    pkt1=0+dpkt1p_hv25_spw    lat=0+dlatp_hv25_spw
+ wat=0+dwatp_hv25_spw      pat=0+dpatp_hv25_spw      lagidl=0+dlagidlp_hv25_spw
+ wagidl=0+dwagidlp_hv25_spw                          pagidl=0+dpagidlp_hv25_spw
+ wbgidl=0+dwbgidlp_hv25_spw                          pbgidl=0+dpbgidlp_hv25_spw
+ minr=1e-3

     4: type=p
+ lmin=1e-005-dxlp_hv25_spw lmax=0.000900001          wmin=1e-005-dxwp_hv25_spw
+ wmax=2e-005-dxwp_hv25_spw version=4.5               binunit=2
+ paramchk=1                mobmod=0                  capmod=2
+ igcmod=0                  igbmod=0                  diomod=1
+ rdsmod=1                  rbodymod=0                rgeomod=1
+ rgatemod=1*rgflag_hv25_snw_spw                      permod=1
+ acnqsmod=0                trnqsmod=0                tempmod=0
+ tnom=25                   toxe=toxp_hv25_spw        toxm=6.13e-009
+ dtox=3.9839e-010          epsrox=3.9                wint=0
+ lint=1.61e-007            ll=0                      wl=0
+ lln=1                     wln=1                     lw=0
+ ww=0                      lwn=1                     wwn=1
+ lwl=0                     wwl=0                     llc=0
+ wlc=0                     lwc=0                     wwc=0
+ lwlc=0                    wwlc=0                    xl=2.2e-08+dxlp_hv25_spw
+ xw=0+dxwp_hv25_spw        dlc=ddlcp_hv25_spw        dwc=0
+ xpart=1                   toxref=3e-009             dlcig=2.5e-009
+ vth0=-0.77256+dvthp_hv25_spw                        lvth0=-1.9611438e-013+dlvthp_hv25_spw
+ wvth0=1.6e-007+dwvthp_hv25_spw                      pvth0=1.9611437e-018+dpvthp_hv25_spw
+ k1=0.52871                k2=0.053099               k3=-2.3465
+ k3b=1                     w0=0                      dvt0=0.85946
+ dvt1=0.034455             dvt2=0                    dvt0w=0
+ dvt1w=0                   dvt2w=0                   dsub=0.33
+ minv=-0.29912             voffl=-5e-009             dvtp0=3e-007
+ dvtp1=0.1                 lpe0=6.3e-008             lpeb=3.1121e-009
+ xj=8.5e-008               ngate=2.092e+020          ndep=6e+017
+ nsd=1e+020                phin=0.174                cdsc=0
+ cdscb=0                   cdscd=0                   cit=0.0009+dcitp_hv25_spw
+ wcit=-2e-009+dwcitp_hv25_spw                        voff=-0.14+dvoffp_hv25_spw
+ wvoff=1e-007+dwvoffp_hv25_spw                       nfactor=0.7+dnfactorp_hv25_spw
+ eta0=0.05+deta0p_hv25_spw etab=-0.0847              ud=0
+ lud=0                     wud=0                     pud=0
+ u0=0.012+du0p_hv25_spw    ua=1.7974e-009            lua=1.9611438e-021
+ wua=-4.666e-015           pua=-1.9611438e-026       ub=-1.84304e-019
+ lub=7.8445752e-032        wub=5.42084e-024          pub=-7.8445749e-037
+ uc=-1.6e-011              vsat=90000+dvsatp_hv25_spw
+ a0=-0.17663+da0p_hv25_spw wa0=4.764e-007+dwa0p_hv25_spw
+ ags=3.7754+dagsp_hv25_spw a1=0                      a2=1
+ b0=0                      b1=0                      keta=-0.061176
+ dwg=0                     dwb=0                     pclm=0.05
+ pdiblc1=0                 pdiblc2=0.0001            pdiblcb=0
+ drout=0.56                pvag=0                    delta=0.01
+ pscbe1=9.264e+008         pscbe2=1e-020             fprout=100
+ pdits=0                   pditsd=0                  rsh=1.520000e+01
+ rsw=100                   rdw=2088                  prwg=0
+ prwb=0                    wr=1                      alpha0=1.1625e-008
+ alpha1=0.040625           beta0=28.8                agidl=5e-008+dagidlp_hv25_spw
+ bgidl=4.6064e+009+dbgidlp_hv25_spw                  lbgidl=-0.00098057191+dlbgidlp_hv25_spw
+ wbgidl=-3640+dwbgidlp_hv25_spw                      pbgidl=1.9611438e-008+dpbgidlp_hv25_spw
+ cgidl=10                  egidl=0.902               aigbacc=0.01238
+ bigbacc=0.006109          cigbacc=0.2809            nigbacc=4.05
+ aigbinv=0.35              bigbinv=0.03              cigbinv=0.006
+ eigbinv=1.1               nigbinv=1                 aigc=0.009898
+ bigc=0.001383             cigc=1.515e-005           aigsd=0.0086
+ bigsd=0.0004353           cigsd=3.925e-020          nigc=1
+ poxedge=1                 pigcd=1.672               ntox=1
+ xrcrg1=12                 xrcrg2=1                  cgso=cgsop_hv25_spw
+ cgdo=cgdop_hv25_spw       cgbo=0                    cgdl=cgdlp_hv25_spw
+ cgsl=cgslp_hv25_spw       clc=1e-007                cle=0.6
+ cf=cfp_hv25_spw           ckappas=0.6               ckappad=0.6
+ acde=0.7                  moin=6.4033               noff=1.7249
+ voffcv=-0.058992          tvoff=0.001               ltvoff=0
+ wtvoff=0                  ptvoff=0                  kt1=-0.36251+dkt1p_hv25_spw
+ wkt1=2.12e-007+dwkt1p_hv25_spw                      kt1l=0
+ kt2=-0.101977             wkt2=5.3988e-007          ute=-1.5
+ ua1=-1.58328e-009         wua1=9.0196e-015          ub1=1.42122e-018
+ wub1=-1.31822e-023        uc1=3.8065e-011           prt=0
+ at=-120000+datp_hv25_spw  jss=1.540000e-07          jsws=4.710000e-13
+ jswgs=4.710000e-13        njs=1.02                  njd=1.02
+ ijthsfwd=0.01             ijthdfwd=0.01             ijthsrev=0.01
+ ijthdrev=0.01             bvs=8.700000e+00          xjbvs=1
+ xjbvd=1                   jsd=1.012800e-07          jswd=3.752600e-13
+ jswgd=3.752600e-13        bvd=1.430000e+01          jtsswgs=1e-010+djtsswgsp_hv25_spw
+ jtsswgd=5.3e-009+djtsswgdp_hv25_spw                 njtsswg=9+dnjtsswgp_hv25_spw
+ xtsswgs=0.1               xtsswgd=0.43              tnjtsswg=1
+ vtsswgs=1                 vtsswgd=1                 pbs=8.000000e-01
+ cjs=cjsp_hv25_spw         mjs=3.400000e-01          pbsws=4.500000e-01
+ cjsws=cjswsp_hv25_spw     mjsws=1.480000e-01        pbswgs=5.500000e-01
+ cjswgs=cjswgsp_hv25_spw   mjswgs=4.500000e-01       pbd=6.600000e-01
+ cjd=cjdp_hv25_spw         mjd=3.300000e-01          pbswd=6.500000e-01
+ cjswd=cjswdp_hv25_spw     mjswd=3.400000e-01        pbswgd=7.000000e-01
+ cjswgd=cjswgdp_hv25_spw   mjswgd=4.000000e-01       tpb=1.550000e-03
+ tcj=1.100000e-03          tpbsw=1.550000e-03        tcjsw=1.100000e-03
+ tpbswg=1.500000e-03       tcjswg=1.170000e-03       xtis=3
+ xtid=3                    dmcg=5.800000e-08         dmci=5.800000e-08
+ dmdg=0                    dmcgt=0                   dwj=0
+ xgw=0                     xgl=-8.200000e-09         rshg=1.410000e+01
+ gbmin=1e-012              rbpb=50                   rbpd=50
+ rbps=50                   rbdb=50                   rbsb=50
+ ngcon=1                   lcit=0+dlcitp_hv25_spw    pcit=0+dpcitp_hv25_spw
+ lu0=0+dlu0p_hv25_spw      wu0=0+dwu0p_hv25_spw      pu0=0+dpu0p_hv25_spw
+ la0=0+dla0p_hv25_spw      pa0=0+dpa0p_hv25_spw      lags=0+dlagsp_hv25_spw
+ wags=0+dwagsp_hv25_spw    pags=0+dpagsp_hv25_spw    lvsat=0+dlvsatp_hv25_spw
+ wnfactor=0+dwnfactorp_hv25_spw                      lnfactor=0+dlnfactorp_hv25_spw
+ pnfactor=0+dpnfactorp_hv25_spw                      pvsat=0+dpvsatp_hv25_spw
+ wvsat=0+dwvsatp_hv25_spw  lvoff=0+dlvoffp_hv25_spw  pvoff=0+dpvoffp_hv25_spw
+ lkt1=0+dlkt1p_hv25_spw    pkt1=0+dpkt1p_hv25_spw    lat=0+dlatp_hv25_spw
+ wat=0+dwatp_hv25_spw      pat=0+dpatp_hv25_spw      lagidl=0+dlagidlp_hv25_spw
+ wagidl=0+dwagidlp_hv25_spw                          pagidl=0+dpagidlp_hv25_spw
+ minr=1e-3

     5: type=p
+ lmin=9e-007-dxlp_hv25_spw lmax=1e-005-dxlp_hv25_spw wmin=1e-005-dxwp_hv25_spw
+ wmax=2e-005-dxwp_hv25_spw version=4.5               binunit=2
+ paramchk=1                mobmod=0                  capmod=2
+ igcmod=0                  igbmod=0                  diomod=1
+ rdsmod=1                  rbodymod=0                rgeomod=1
+ rgatemod=1*rgflag_hv25_snw_spw                      permod=1
+ acnqsmod=0                trnqsmod=0                tempmod=0
+ tnom=25                   toxe=toxp_hv25_spw        toxm=6.13e-009
+ dtox=3.9839e-010          epsrox=3.9                wint=0
+ lint=1.61e-007            ll=0                      wl=0
+ lln=1                     wln=1                     lw=0
+ ww=0                      lwn=1                     wwn=1
+ lwl=0                     wwl=0                     llc=0
+ wlc=0                     lwc=0                     wwc=0
+ lwlc=0                    wwlc=0                    xl=2.2e-08+dxlp_hv25_spw
+ xw=0+dxwp_hv25_spw        dlc=ddlcp_hv25_spw        dwc=0
+ xpart=1                   toxref=3e-009             dlcig=2.5e-009
+ vth0=-0.7816853+dvthp_hv25_spw                      lvth0=8.8515178e-008+dlvthp_hv25_spw
+ wvth0=1.7147274e-007+dwvthp_hv25_spw                pvth0=-1.1128364e-013+dpvthp_hv25_spw
+ k1=0.52871                k2=0.053099               k3=-2.3465
+ k3b=1                     w0=0                      dvt0=0.85946
+ dvt1=0.034455             dvt2=0                    dvt0w=0
+ dvt1w=0                   dvt2w=0                   dsub=0.33
+ minv=-0.29912             voffl=-5e-009             dvtp0=3e-007
+ dvtp1=0.1                 lpe0=6.3e-008             lpeb=3.1121e-009
+ xj=8.5e-008               ngate=2.092e+020          ndep=6e+017
+ nsd=1e+020                phin=0.174                cdsc=0
+ cdscb=0                   cdscd=0                   cit=0.0009+dcitp_hv25_spw
+ wcit=-2e-009+dwcitp_hv25_spw                        voff=-0.14204396+dvoffp_hv25_spw
+ lvoff=1.9826374e-008+dlvoffp_hv25_spw               wvoff=1.0527472e-007+dwvoffp_hv25_spw
+ pvoff=-5.1164835e-014+dpvoffp_hv25_spw              nfactor=0.7+dnfactorp_hv25_spw
+ eta0=0.05+deta0p_hv25_spw etab=-0.0847              ud=0
+ lud=0                     wud=0                     pud=0
+ u0=0.012+du0p_hv25_spw    ua=1.8392486e-009         lua=-4.0592914e-016
+ wua=-4.8892549e-015       pua=2.1655529e-021        ub=-2.042447e-019
+ lub=1.9342482e-025        wub=5.7630931e-024        pub=-3.3198559e-030
+ uc=-1.6e-011              vsat=90000+dvsatp_hv25_spw
+ a0=-0.18497923+da0p_hv25_spw                        la0=8.0987538e-008+dla0p_hv25_spw
+ wa0=5.0781099e-007+dwa0p_hv25_spw                   pa0=-3.0468659e-013+dpa0p_hv25_spw
+ ags=3.8267231+dagsp_hv25_spw                        lags=-4.9783385e-007+dlagsp_hv25_spw
+ wags=-7.1986813e-007+dwagsp_hv25_spw                pags=6.9827209e-012+dpagsp_hv25_spw
+ a1=0                      a2=1                      b0=0
+ b1=0                      keta=-0.061176            dwg=0
+ dwb=0                     pclm=0.043406593          lpclm=6.3956044e-008
+ pdiblc1=0                 pdiblc2=0.0001            pdiblcb=0
+ drout=0.56                pvag=0                    delta=0.01
+ pscbe1=9.264e+008         pscbe2=1e-020             fprout=100
+ pdits=0                   pditsd=0                  rsh=1.520000e+01
+ rsw=100                   rdw=2088                  prwg=0
+ prwb=0                    wr=1                      alpha0=1.1625e-008
+ alpha1=0.040625           beta0=28.8                agidl=5e-008+dagidlp_hv25_spw
+ bgidl=4.6063999e+009+dbgidlp_hv25_spw               lbgidl=6.3956043e-005+dlbgidlp_hv25_spw
+ wbgidl=-3639.9979+dwbgidlp_hv25_spw                 pbgidl=-1.2791209e-009+dpbgidlp_hv25_spw
+ cgidl=10                  egidl=0.902               aigbacc=0.01238
+ bigbacc=0.006109          cigbacc=0.2809            nigbacc=4.05
+ aigbinv=0.35              bigbinv=0.03              cigbinv=0.006
+ eigbinv=1.1               nigbinv=1                 aigc=0.009898
+ bigc=0.001383             cigc=1.515e-005           aigsd=0.0086
+ bigsd=0.0004353           cigsd=3.925e-020          nigc=1
+ poxedge=1                 pigcd=1.672               ntox=1
+ xrcrg1=12                 xrcrg2=1                  cgso=cgsop_hv25_spw
+ cgdo=cgdop_hv25_spw       cgbo=0                    cgdl=cgdlp_hv25_spw
+ cgsl=cgslp_hv25_spw       clc=1e-007                cle=0.6
+ cf=cfp_hv25_spw           ckappas=0.6               ckappad=0.6
+ acde=0.7                  moin=6.4033               noff=1.7249
+ voffcv=-0.058992          tvoff=0.001               ltvoff=0
+ wtvoff=0                  ptvoff=0                  kt1=-0.36251+dkt1p_hv25_spw
+ wkt1=2.12e-007+dwkt1p_hv25_spw                      kt1l=0
+ kt2=-0.101977             wkt2=5.3988e-007          ute=-1.5
+ ua1=-1.58328e-009         wua1=9.0196e-015          ub1=1.42122e-018
+ wub1=-1.31822e-023        uc1=3.8065e-011           prt=0
+ at=-120000+datp_hv25_spw  jss=1.540000e-07          jsws=4.710000e-13
+ jswgs=4.710000e-13        njs=1.02                  njd=1.02
+ ijthsfwd=0.01             ijthdfwd=0.01             ijthsrev=0.01
+ ijthdrev=0.01             bvs=8.700000e+00          xjbvs=1
+ xjbvd=1                   jsd=1.012800e-07          jswd=3.752600e-13
+ jswgd=3.752600e-13        bvd=1.430000e+01          jtsswgs=1e-010+djtsswgsp_hv25_spw
+ jtsswgd=5.3e-009+djtsswgdp_hv25_spw                 njtsswg=9+dnjtsswgp_hv25_spw
+ xtsswgs=0.1               xtsswgd=0.43              tnjtsswg=1
+ vtsswgs=1                 vtsswgd=1                 pbs=8.000000e-01
+ cjs=cjsp_hv25_spw         mjs=3.400000e-01          pbsws=4.500000e-01
+ cjsws=cjswsp_hv25_spw     mjsws=1.480000e-01        pbswgs=5.500000e-01
+ cjswgs=cjswgsp_hv25_spw   mjswgs=4.500000e-01       pbd=6.600000e-01
+ cjd=cjdp_hv25_spw         mjd=3.300000e-01          pbswd=6.500000e-01
+ cjswd=cjswdp_hv25_spw     mjswd=3.400000e-01        pbswgd=7.000000e-01
+ cjswgd=cjswgdp_hv25_spw   mjswgd=4.000000e-01       tpb=1.550000e-03
+ tcj=1.100000e-03          tpbsw=1.550000e-03        tcjsw=1.100000e-03
+ tpbswg=1.500000e-03       tcjswg=1.170000e-03       xtis=3
+ xtid=3                    dmcg=5.800000e-08         dmci=5.800000e-08
+ dmdg=0                    dmcgt=0                   dwj=0
+ xgw=0                     xgl=-8.200000e-09         rshg=1.410000e+01
+ gbmin=1e-012              rbpb=50                   rbpd=50
+ rbps=50                   rbdb=50                   rbsb=50
+ ngcon=1                   lcit=0+dlcitp_hv25_spw    pcit=0+dpcitp_hv25_spw
+ lu0=0+dlu0p_hv25_spw      wu0=0+dwu0p_hv25_spw      pu0=0+dpu0p_hv25_spw
+ lvsat=0+dlvsatp_hv25_spw  wnfactor=0+dwnfactorp_hv25_spw
+ lnfactor=0+dlnfactorp_hv25_spw                      pnfactor=0+dpnfactorp_hv25_spw
+ pvsat=0+dpvsatp_hv25_spw  wvsat=0+dwvsatp_hv25_spw  lkt1=0+dlkt1p_hv25_spw
+ pkt1=0+dpkt1p_hv25_spw    lat=0+dlatp_hv25_spw      wat=0+dwatp_hv25_spw
+ pat=0+dpatp_hv25_spw      lagidl=0+dlagidlp_hv25_spw
+ wagidl=0+dwagidlp_hv25_spw                          pagidl=0+dpagidlp_hv25_spw
+ minr=1e-3

     6: type=p
+ lmin=5.94e-07             lmax=9e-007-dxlp_hv25_spw wmin=1e-005-dxwp_hv25_spw
+ wmax=2e-005-dxwp_hv25_spw version=4.5               binunit=2
+ paramchk=1                mobmod=0                  capmod=2
+ igcmod=0                  igbmod=0                  diomod=1
+ rdsmod=1                  rbodymod=0                rgeomod=1
+ rgatemod=1*rgflag_hv25_snw_spw                      permod=1
+ acnqsmod=0                trnqsmod=0                tempmod=0
+ tnom=25                   toxe=toxp_hv25_spw        toxm=6.13e-009
+ dtox=3.9839e-010          epsrox=3.9                wint=0
+ lint=1.61e-007            ll=0                      wl=0
+ lln=1                     wln=1                     lw=0
+ ww=0                      lwn=1                     wwn=1
+ lwl=0                     wwl=0                     llc=0
+ wlc=0                     lwc=0                     wwc=0
+ lwlc=0                    wwlc=0                    xl=2.2e-08+dxlp_hv25_spw
+ xw=0+dxwp_hv25_spw        dlc=ddlcp_hv25_spw        dwc=0
+ xpart=1                   toxref=3e-009             dlcig=2.5e-009
+ vth0=-0.63161+dvthp_hv25_spw                        lvth0=-1.53e-009+dlvthp_hv25_spw
+ wvth0=-2.8e-008+dwvthp_hv25_spw                     pvth0=8.4e-015+dpvthp_hv25_spw
+ k1=0.52871                k2=0.076499               lk2=-1.404e-008
+ k3=-2.3465                k3b=1                     w0=0
+ dvt0=0.85946              dvt1=0.034455             dvt2=0
+ dvt0w=0                   dvt1w=0                   dvt2w=0
+ dsub=0.33                 minv=-0.29912             voffl=-5e-009
+ dvtp0=3e-007              dvtp1=0.1                 lpe0=6.3e-008
+ lpeb=3.1121e-009          xj=8.5e-008               ngate=2.092e+020
+ ndep=6e+017               nsd=1e+020                phin=0.174
+ cdsc=0                    cdscb=0                   cdscd=0
+ cit=0.0007+dcitp_hv25_spw lcit=1.2e-010+dlcitp_hv25_spw
+ wcit=-1.1709383e-023+dwcitp_hv25_spw                pcit=-1.2e-015+dpcitp_hv25_spw
+ voff=-0.123+dvoffp_hv25_spw                         lvoff=8.4e-009+dlvoffp_hv25_spw
+ wvoff=4e-008+dwvoffp_hv25_spw                       pvoff=-1.2e-014+dpvoffp_hv25_spw
+ nfactor=0.7+dnfactorp_hv25_spw                      eta0=0.03+deta0p_hv25_spw
+ leta0=1.2e-008            etab=-0.0847              ud=0
+ lud=0                     wud=0                     pud=0
+ u0=0.007+du0p_hv25_spw    lu0=3e-009+dlu0p_hv25_spw wu0=-2e-008+dwu0p_hv25_spw
+ pu0=1.2e-014+dpu0p_hv25_spw                         ua=-4.108e-010
+ lua=9.441e-016            wua=-7.014e-015           pua=3.4404e-021
+ ub=1.08138e-018           lub=-5.7795e-025          wub=2.0698e-024
+ pub=-1.10388e-030         uc=6.2499e-011            luc=-4.70994e-017
+ vsat=90000+dvsatp_hv25_spw                          a0=0.3+da0p_hv25_spw
+ la0=-2.1e-007+dla0p_hv25_spw                        ags=4.509+dagsp_hv25_spw
+ lags=-9.072e-007+dlagsp_hv25_spw                    wags=2.1836e-005+dwagsp_hv25_spw
+ pags=-6.5508e-012+dpagsp_hv25_spw                   a1=0
+ a2=1                      b0=0                      b1=0
+ keta=-0.061176            dwg=0                     dwb=0
+ pclm=-0.1                 lpclm=1.5e-007            pdiblc1=0
+ pdiblc2=0.0001            pdiblcb=0                 drout=0.56
+ pvag=0                    delta=0.01                pscbe1=9.264e+008
+ pscbe2=1e-020             fprout=100                pdits=0
+ pditsd=0                  rsh=1.520000e+01          rsw=100
+ rdw=2088                  prwg=0                    prwb=0
+ wr=1                      alpha0=1.1625e-008        alpha1=0.040625
+ beta0=28.8                agidl=5e-008+dagidlp_hv25_spw
+ bgidl=4.4414e+009+dbgidlp_hv25_spw                  lbgidl=99+dlbgidlp_hv25_spw
+ wbgidl=-3004+dwbgidlp_hv25_spw                      pbgidl=-0.0003816+dpbgidlp_hv25_spw
+ cgidl=10                  egidl=0.902               aigbacc=0.01238
+ bigbacc=0.006109          cigbacc=0.2809            nigbacc=4.05
+ aigbinv=0.35              bigbinv=0.03              cigbinv=0.006
+ eigbinv=1.1               nigbinv=1                 aigc=0.009898
+ bigc=0.001383             cigc=1.515e-005           aigsd=0.0086
+ bigsd=0.0004353           cigsd=3.925e-020          nigc=1
+ poxedge=1                 pigcd=1.672               ntox=1
+ xrcrg1=12                 xrcrg2=1                  cgso=cgsop_hv25_spw
+ cgdo=cgdop_hv25_spw       cgbo=0                    cgdl=cgdlp_hv25_spw
+ cgsl=cgslp_hv25_spw       clc=1e-007                cle=0.6
+ cf=cfp_hv25_spw           ckappas=0.6               ckappad=0.6
+ acde=0.7                  moin=6.4033               noff=1.7249
+ voffcv=-0.058992          tvoff=0.001               ltvoff=0
+ wtvoff=0                  ptvoff=0                  kt1=-0.34648+dkt1p_hv25_spw
+ lkt1=-9.618e-009+dlkt1p_hv25_spw                    wkt1=1.802e-007+dwkt1p_hv25_spw
+ pkt1=1.908e-014+dpkt1p_hv25_spw                     kt1l=0
+ kt2=-0.141718             lkt2=2.38446e-008         wkt2=9.148e-007
+ pkt2=-2.24952e-013        ute=-1.5                  ua1=-2.78904e-009
+ lua1=7.23456e-016         wua1=2.5432e-014          pua1=-9.84744e-021
+ ub1=3.13131e-018          lub1=-1.026054e-024       wub1=-3.42644e-023
+ pub1=1.264932e-029        uc1=3.8065e-011           prt=0
+ at=-120000+datp_hv25_spw  jss=1.540000e-07          jsws=4.710000e-13
+ jswgs=4.710000e-13        njs=1.02                  njd=1.02
+ ijthsfwd=0.01             ijthdfwd=0.01             ijthsrev=0.01
+ ijthdrev=0.01             bvs=8.700000e+00          xjbvs=1
+ xjbvd=1                   jsd=1.012800e-07          jswd=3.752600e-13
+ jswgd=3.752600e-13        bvd=1.430000e+01          jtsswgs=1e-010+djtsswgsp_hv25_spw
+ jtsswgd=5.3e-009+djtsswgdp_hv25_spw                 njtsswg=9+dnjtsswgp_hv25_spw
+ xtsswgs=0.1               xtsswgd=0.43              tnjtsswg=1
+ vtsswgs=1                 vtsswgd=1                 pbs=8.000000e-01
+ cjs=cjsp_hv25_spw         mjs=3.400000e-01          pbsws=4.500000e-01
+ cjsws=cjswsp_hv25_spw     mjsws=1.480000e-01        pbswgs=5.500000e-01
+ cjswgs=cjswgsp_hv25_spw   mjswgs=4.500000e-01       pbd=6.600000e-01
+ cjd=cjdp_hv25_spw         mjd=3.300000e-01          pbswd=6.500000e-01
+ cjswd=cjswdp_hv25_spw     mjswd=3.400000e-01        pbswgd=7.000000e-01
+ cjswgd=cjswgdp_hv25_spw   mjswgd=4.000000e-01       tpb=1.550000e-03
+ tcj=1.100000e-03          tpbsw=1.550000e-03        tcjsw=1.100000e-03
+ tpbswg=1.500000e-03       tcjswg=1.170000e-03       xtis=3
+ xtid=3                    dmcg=5.800000e-08         dmci=5.800000e-08
+ dmdg=0                    dmcgt=0                   dwj=0
+ xgw=0                     xgl=-8.200000e-09         rshg=1.410000e+01
+ gbmin=1e-012              rbpb=50                   rbpd=50
+ rbps=50                   rbdb=50                   rbsb=50
+ ngcon=1                   wa0=0+dwa0p_hv25_spw      pa0=0+dpa0p_hv25_spw
+ lvsat=0+dlvsatp_hv25_spw  wnfactor=0+dwnfactorp_hv25_spw
+ lnfactor=0+dlnfactorp_hv25_spw                      pnfactor=0+dpnfactorp_hv25_spw
+ pvsat=0+dpvsatp_hv25_spw  wvsat=0+dwvsatp_hv25_spw  lat=0+dlatp_hv25_spw
+ wat=0+dwatp_hv25_spw      pat=0+dpatp_hv25_spw      lagidl=0+dlagidlp_hv25_spw
+ wagidl=0+dwagidlp_hv25_spw                          pagidl=0+dpagidlp_hv25_spw
+ minr=1e-3

     7: type=p
+ lmin=1e-005-dxlp_hv25_spw lmax=0.000900001          wmin=5e-006-dxwp_hv25_spw
+ wmax=1e-005-dxwp_hv25_spw version=4.5               binunit=2
+ paramchk=1                mobmod=0                  capmod=2
+ igcmod=0                  igbmod=0                  diomod=1
+ rdsmod=1                  rbodymod=0                rgeomod=1
+ rgatemod=1*rgflag_hv25_snw_spw                      permod=1
+ acnqsmod=0                trnqsmod=0                tempmod=0
+ tnom=25                   toxe=toxp_hv25_spw        toxm=6.13e-009
+ dtox=3.9839e-010          epsrox=3.9                wint=0
+ lint=1.61e-007            ll=0                      wl=0
+ lln=1                     wln=1                     lw=0
+ ww=0                      lwn=1                     wwn=1
+ lwl=0                     wwl=0                     llc=0
+ wlc=0                     lwc=0                     wwc=0
+ lwlc=0                    wwlc=0                    xl=2.2e-08+dxlp_hv25_spw
+ xw=0+dxwp_hv25_spw        dlc=ddlcp_hv25_spw        dwc=0
+ xpart=1                   toxref=3e-009             dlcig=2.5e-009
+ vth0=-0.7653+dvthp_hv25_spw                         wvth0=8.74e-008+dwvthp_hv25_spw
+ k1=0.52871                k2=0.056526               wk2=-3.427e-008
+ k3=-2.3465                k3b=1                     w0=0
+ dvt0=0.85946              dvt1=0.034455             dvt2=0
+ dvt0w=0                   dvt1w=0                   dvt2w=0
+ dsub=0.33                 minv=-0.29912             voffl=-5e-009
+ dvtp0=3e-007              dvtp1=0.1                 lpe0=6.3e-008
+ lpeb=3.1121e-009          xj=8.5e-008               ngate=2.092e+020
+ ndep=6e+017               nsd=1e+020                phin=0.174
+ cdsc=0                    cdscb=0                   cdscd=0
+ cit=0.0008+dcitp_hv25_spw wcit=-1e-009+dwcitp_hv25_spw
+ voff=-0.125+dvoffp_hv25_spw                         wvoff=-5e-008+dwvoffp_hv25_spw
+ nfactor=0.7+dnfactorp_hv25_spw                      eta0=0.05+deta0p_hv25_spw
+ etab=-0.0847              ud=0                      lud=0
+ wud=0                     pud=0                     u0=0.012+du0p_hv25_spw
+ ua=1.2519e-009            wua=7.89e-016             ub=6.4971e-019
+ wub=-2.9193e-024          uc=-1.0168e-011           wuc=-5.832e-017
+ vsat=90000+dvsatp_hv25_spw                          a0=-0.14431+da0p_hv25_spw
+ wa0=1.532e-007+dwa0p_hv25_spw                       ags=3.8047+dagsp_hv25_spw
+ lags=-9.8057189e-013+dlagsp_hv25_spw                wags=-2.9300001e-007+dwagsp_hv25_spw
+ pags=9.8057189e-018+dpagsp_hv25_spw                 a1=0
+ a2=1                      b0=0                      b1=0
+ keta=-0.042903            wketa=-1.8273e-007        dwg=0
+ dwb=0                     pclm=0.05                 pdiblc1=0
+ pdiblc2=0.0001            pdiblcb=0                 drout=0.56
+ pvag=0                    delta=0.01                pscbe1=9.264e+008
+ pscbe2=1e-020             fprout=100                pdits=0
+ pditsd=0                  rsh=1.520000e+01          rsw=100
+ rdw=2088                  prwg=0                    prwb=0
+ wr=1                      alpha0=1.1625e-008        alpha1=0.040625
+ beta0=28.8                agidl=5e-008+dagidlp_hv25_spw
+ bgidl=4.3392e+009+dbgidlp_hv25_spw                  lbgidl=0.0019611438+dlbgidlp_hv25_spw
+ wbgidl=-967.99999+dwbgidlp_hv25_spw                 pbgidl=-9.8057188e-009+dpbgidlp_hv25_spw
+ cgidl=10                  egidl=0.902               aigbacc=0.01238
+ bigbacc=0.006109          cigbacc=0.2809            nigbacc=4.05
+ aigbinv=0.35              bigbinv=0.03              cigbinv=0.006
+ eigbinv=1.1               nigbinv=1                 aigc=0.009898
+ bigc=0.001383             cigc=1.515e-005           aigsd=0.0086
+ bigsd=0.0004353           cigsd=3.925e-020          nigc=1
+ poxedge=1                 pigcd=1.672               ntox=1
+ xrcrg1=12                 xrcrg2=1                  cgso=cgsop_hv25_spw
+ cgdo=cgdop_hv25_spw       cgbo=0                    cgdl=cgdlp_hv25_spw
+ cgsl=cgslp_hv25_spw       clc=1e-007                cle=0.6
+ cf=cfp_hv25_spw           ckappas=0.6               ckappad=0.6
+ acde=0.7                  moin=6.4033               noff=1.7249
+ voffcv=-0.058992          tvoff=0.001               ltvoff=0
+ wtvoff=0                  ptvoff=0                  kt1=-0.34454+dkt1p_hv25_spw
+ wkt1=3.23e-008+dwkt1p_hv25_spw                      kt1l=0
+ kt2=-0.020995             wkt2=-2.6994e-007         ute=-1.5
+ ua1=-4.4475e-010          wua1=-2.3657e-015         ub1=-4.3665e-019
+ wub1=5.3965e-024          uc1=3.8065e-011           prt=0
+ at=-120000+datp_hv25_spw  jss=1.540000e-07          jsws=4.710000e-13
+ jswgs=4.710000e-13        njs=1.02                  njd=1.02
+ ijthsfwd=0.01             ijthdfwd=0.01             ijthsrev=0.01
+ ijthdrev=0.01             bvs=8.700000e+00          xjbvs=1
+ xjbvd=1                   jsd=1.012800e-07          jswd=3.752600e-13
+ jswgd=3.752600e-13        bvd=1.430000e+01          jtsswgs=1e-010+djtsswgsp_hv25_spw
+ jtsswgd=5.3e-009+djtsswgdp_hv25_spw                 njtsswg=9+dnjtsswgp_hv25_spw
+ xtsswgs=0.1               xtsswgd=0.43              tnjtsswg=1
+ vtsswgs=1                 vtsswgd=1                 pbs=8.000000e-01
+ cjs=cjsp_hv25_spw         mjs=3.400000e-01          pbsws=4.500000e-01
+ cjsws=cjswsp_hv25_spw     mjsws=1.480000e-01        pbswgs=5.500000e-01
+ cjswgs=cjswgsp_hv25_spw   mjswgs=4.500000e-01       pbd=6.600000e-01
+ cjd=cjdp_hv25_spw         mjd=3.300000e-01          pbswd=6.500000e-01
+ cjswd=cjswdp_hv25_spw     mjswd=3.400000e-01        pbswgd=7.000000e-01
+ cjswgd=cjswgdp_hv25_spw   mjswgd=4.000000e-01       tpb=1.550000e-03
+ tcj=1.100000e-03          tpbsw=1.550000e-03        tcjsw=1.100000e-03
+ tpbswg=1.500000e-03       tcjswg=1.170000e-03       xtis=3
+ xtid=3                    dmcg=5.800000e-08         dmci=5.800000e-08
+ dmdg=0                    dmcgt=0                   dwj=0
+ xgw=0                     xgl=-8.200000e-09         rshg=1.410000e+01
+ gbmin=1e-012              rbpb=50                   rbpd=50
+ rbps=50                   rbdb=50                   rbsb=50
+ ngcon=1                   lvth0=0+dlvthp_hv25_spw   pvth0=0+dpvthp_hv25_spw
+ lcit=0+dlcitp_hv25_spw    pcit=0+dpcitp_hv25_spw    lu0=0+dlu0p_hv25_spw
+ wu0=0+dwu0p_hv25_spw      pu0=0+dpu0p_hv25_spw      la0=0+dla0p_hv25_spw
+ pa0=0+dpa0p_hv25_spw      lvsat=0+dlvsatp_hv25_spw  wnfactor=0+dwnfactorp_hv25_spw
+ lnfactor=0+dlnfactorp_hv25_spw                      pnfactor=0+dpnfactorp_hv25_spw
+ pvsat=0+dpvsatp_hv25_spw  wvsat=0+dwvsatp_hv25_spw  lvoff=0+dlvoffp_hv25_spw
+ pvoff=0+dpvoffp_hv25_spw  lkt1=0+dlkt1p_hv25_spw    pkt1=0+dpkt1p_hv25_spw
+ lat=0+dlatp_hv25_spw      wat=0+dwatp_hv25_spw      pat=0+dpatp_hv25_spw
+ lagidl=0+dlagidlp_hv25_spw                          wagidl=0+dwagidlp_hv25_spw
+ pagidl=0+dpagidlp_hv25_spw                          minr=1e-3

     8: type=p
+ lmin=9e-007-dxlp_hv25_spw lmax=1e-005-dxlp_hv25_spw wmin=5e-006-dxwp_hv25_spw
+ wmax=1e-005-dxwp_hv25_spw version=4.5               binunit=2
+ paramchk=1                mobmod=0                  capmod=2
+ igcmod=0                  igbmod=0                  diomod=1
+ rdsmod=1                  rbodymod=0                rgeomod=1
+ rgatemod=1*rgflag_hv25_snw_spw                      permod=1
+ acnqsmod=0                trnqsmod=0                tempmod=0
+ tnom=25                   toxe=toxp_hv25_spw        toxm=6.13e-009
+ dtox=3.9839e-010          epsrox=3.9                wint=0
+ lint=1.61e-007            ll=0                      wl=0
+ lln=1                     wln=1                     lw=0
+ ww=0                      lwn=1                     wwn=1
+ lwl=0                     wwl=0                     llc=0
+ wlc=0                     lwc=0                     wwc=0
+ lwlc=0                    wwlc=0                    xl=2.2e-08+dxlp_hv25_spw
+ xw=0+dxwp_hv25_spw        dlc=ddlcp_hv25_spw        dwc=0
+ xpart=1                   toxref=3e-009             dlcig=2.5e-009
+ vth0=-0.77394659+dvthp_hv25_spw                     lvth0=8.3871956e-008+dlvthp_hv25_spw
+ wvth0=9.4085714e-008+dwvthp_hv25_spw                pvth0=-6.4851429e-014+dpvthp_hv25_spw
+ k1=0.52871                k2=0.056526               wk2=-3.427e-008
+ k3=-2.3465                k3b=1                     w0=0
+ dvt0=0.85946              dvt1=0.034455             dvt2=0
+ dvt0w=0                   dvt1w=0                   dvt2w=0
+ dsub=0.33                 minv=-0.29912             voffl=-5e-009
+ dvtp0=3e-007              dvtp1=0.1                 lpe0=6.3e-008
+ lpeb=3.1121e-009          xj=8.5e-008               ngate=2.092e+020
+ ndep=6e+017               nsd=1e+020                phin=0.174
+ cdsc=0                    cdscb=0                   cdscd=0
+ cit=0.0008+dcitp_hv25_spw wcit=-1e-009+dwcitp_hv25_spw
+ voff=-0.12651648+dvoffp_hv25_spw                    lvoff=1.470989e-008+dlvoffp_hv25_spw
+ wvoff=-5e-008+dwvoffp_hv25_spw                      pvoff=9.7565469e-029+dpvoffp_hv25_spw
+ nfactor=0.7+dnfactorp_hv25_spw                      eta0=0.05+deta0p_hv25_spw
+ etab=-0.0847              ud=0                      lud=0
+ wud=0                     pud=0                     u0=0.012+du0p_hv25_spw
+ ua=1.2612547e-009         lua=-9.0740835e-017       wua=8.9068352e-016
+ pua=-9.8633011e-022       ub=6.8368912e-019         lub=-3.2959747e-025
+ wub=-3.116245e-024        pub=1.910367e-030         uc=-1.0168e-011
+ wuc=-5.832e-017           vsat=90000+dvsatp_hv25_spw
+ a0=-0.15052824+da0p_hv25_spw                        la0=6.0316945e-008+dla0p_hv25_spw
+ wa0=1.633011e-007+dwa0p_hv25_spw                    pa0=-9.7980659e-014+dpa0p_hv25_spw
+ ags=3.8114911+dagsp_hv25_spw                        lags=-6.5874661e-008+dlagsp_hv25_spw
+ wags=-5.6754838e-007+dwagsp_hv25_spw                pags=2.663129e-012+dpagsp_hv25_spw
+ a1=0                      a2=1                      b0=0
+ b1=0                      keta=-0.042903            wketa=-1.8273e-007
+ dwg=0                     dwb=0                     pclm=0.043406593
+ lpclm=6.3956044e-008      pdiblc1=0                 pdiblc2=0.0001
+ pdiblcb=0                 drout=0.56                pvag=0
+ delta=0.01                pscbe1=9.264e+008         pscbe2=1e-020
+ fprout=100                pdits=0                   pditsd=0
+ rsh=1.520000e+01          rsw=100                   rdw=2088
+ prwg=0                    prwb=0                    wr=1
+ alpha0=1.1625e-008        alpha1=0.040625           beta0=28.8
+ agidl=5e-008+dagidlp_hv25_spw                       bgidl=4.3410596e+009+dbgidlp_hv25_spw
+ lbgidl=-18.035732+dlbgidlp_hv25_spw                 wbgidl=-986.59447+dwbgidlp_hv25_spw
+ pbgidl=0.00018035668+dpbgidlp_hv25_spw              cgidl=10
+ egidl=0.902               aigbacc=0.01238           bigbacc=0.006109
+ cigbacc=0.2809            nigbacc=4.05              aigbinv=0.35
+ bigbinv=0.03              cigbinv=0.006             eigbinv=1.1
+ nigbinv=1                 aigc=0.009898             bigc=0.001383
+ cigc=1.515e-005           aigsd=0.0086              bigsd=0.0004353
+ cigsd=3.925e-020          nigc=1                    poxedge=1
+ pigcd=1.672               ntox=1                    xrcrg1=12
+ xrcrg2=1                  cgso=cgsop_hv25_spw       cgdo=cgdop_hv25_spw
+ cgbo=0                    cgdl=cgdlp_hv25_spw       cgsl=cgslp_hv25_spw
+ clc=1e-007                cle=0.6                   cf=cfp_hv25_spw
+ ckappas=0.6               ckappad=0.6               acde=0.7
+ moin=6.4033               noff=1.7249               voffcv=-0.058992
+ tvoff=0.001               ltvoff=0                  wtvoff=0
+ ptvoff=0                  kt1=-0.34454+dkt1p_hv25_spw
+ wkt1=3.23e-008+dwkt1p_hv25_spw                      kt1l=0
+ kt2=-0.020995             wkt2=-2.6994e-007         ute=-1.5
+ ua1=-4.4475e-010          wua1=-2.3657e-015         ub1=-4.3665e-019
+ wub1=5.3965e-024          uc1=3.8065e-011           prt=0
+ at=-120000+datp_hv25_spw  jss=1.540000e-07          jsws=4.710000e-13
+ jswgs=4.710000e-13        njs=1.02                  njd=1.02
+ ijthsfwd=0.01             ijthdfwd=0.01             ijthsrev=0.01
+ ijthdrev=0.01             bvs=8.700000e+00          xjbvs=1
+ xjbvd=1                   jsd=1.012800e-07          jswd=3.752600e-13
+ jswgd=3.752600e-13        bvd=1.430000e+01          jtsswgs=1e-010+djtsswgsp_hv25_spw
+ jtsswgd=5.3e-009+djtsswgdp_hv25_spw                 njtsswg=9+dnjtsswgp_hv25_spw
+ xtsswgs=0.1               xtsswgd=0.43              tnjtsswg=1
+ vtsswgs=1                 vtsswgd=1                 pbs=8.000000e-01
+ cjs=cjsp_hv25_spw         mjs=3.400000e-01          pbsws=4.500000e-01
+ cjsws=cjswsp_hv25_spw     mjsws=1.480000e-01        pbswgs=5.500000e-01
+ cjswgs=cjswgsp_hv25_spw   mjswgs=4.500000e-01       pbd=6.600000e-01
+ cjd=cjdp_hv25_spw         mjd=3.300000e-01          pbswd=6.500000e-01
+ cjswd=cjswdp_hv25_spw     mjswd=3.400000e-01        pbswgd=7.000000e-01
+ cjswgd=cjswgdp_hv25_spw   mjswgd=4.000000e-01       tpb=1.550000e-03
+ tcj=1.100000e-03          tpbsw=1.550000e-03        tcjsw=1.100000e-03
+ tpbswg=1.500000e-03       tcjswg=1.170000e-03       xtis=3
+ xtid=3                    dmcg=5.800000e-08         dmci=5.800000e-08
+ dmdg=0                    dmcgt=0                   dwj=0
+ xgw=0                     xgl=-8.200000e-09         rshg=1.410000e+01
+ gbmin=1e-012              rbpb=50                   rbpd=50
+ rbps=50                   rbdb=50                   rbsb=50
+ ngcon=1                   lcit=0+dlcitp_hv25_spw    pcit=0+dpcitp_hv25_spw
+ lu0=0+dlu0p_hv25_spw      wu0=0+dwu0p_hv25_spw      pu0=0+dpu0p_hv25_spw
+ lvsat=0+dlvsatp_hv25_spw  wnfactor=0+dwnfactorp_hv25_spw
+ lnfactor=0+dlnfactorp_hv25_spw                      pnfactor=0+dpnfactorp_hv25_spw
+ pvsat=0+dpvsatp_hv25_spw  wvsat=0+dwvsatp_hv25_spw  lkt1=0+dlkt1p_hv25_spw
+ pkt1=0+dpkt1p_hv25_spw    lat=0+dlatp_hv25_spw      wat=0+dwatp_hv25_spw
+ pat=0+dpatp_hv25_spw      lagidl=0+dlagidlp_hv25_spw
+ wagidl=0+dwagidlp_hv25_spw                          pagidl=0+dpagidlp_hv25_spw
+ minr=1e-3

     9: type=p
+ lmin=5.94e-07             lmax=9e-007-dxlp_hv25_spw wmin=5e-006-dxwp_hv25_spw
+ wmax=1e-005-dxwp_hv25_spw version=4.5               binunit=2
+ paramchk=1                mobmod=0                  capmod=2
+ igcmod=0                  igbmod=0                  diomod=1
+ rdsmod=1                  rbodymod=0                rgeomod=1
+ rgatemod=1*rgflag_hv25_snw_spw                      permod=1
+ acnqsmod=0                trnqsmod=0                tempmod=0
+ tnom=25                   toxe=toxp_hv25_spw        toxm=6.13e-009
+ dtox=3.9839e-010          epsrox=3.9                wint=0
+ lint=1.61e-007            ll=0                      wl=0
+ lln=1                     wln=1                     lw=0
+ ww=0                      lwn=1                     wwn=1
+ lwl=0                     wwl=0                     llc=0
+ wlc=0                     lwc=0                     wwc=0
+ lwlc=0                    wwlc=0                    xl=2.2e-08+dxlp_hv25_spw
+ xw=0+dxwp_hv25_spw        dlc=ddlcp_hv25_spw        dwc=0
+ xpart=1                   toxref=3e-009             dlcig=2.5e-009
+ vth0=-0.63504+dvthp_hv25_spw                        lvth0=5.28e-010+dlvthp_hv25_spw
+ wvth0=6.3e-009+dwvthp_hv25_spw                      pvth0=-1.218e-014+dpvthp_hv25_spw
+ k1=0.52871                k2=0.082294               lk2=-1.54608e-008
+ wk2=-5.795e-008           pk2=1.4208e-014           k3=-2.3465
+ k3b=1                     w0=0                      dvt0=0.85946
+ dvt1=0.034455             dvt2=0                    dvt0w=0
+ dvt1w=0                   dvt2w=0                   dsub=0.33
+ minv=-0.29912             voffl=-5e-009             dvtp0=3e-007
+ dvtp1=0.1                 lpe0=6.3e-008             lpeb=3.1121e-009
+ xj=8.5e-008               ngate=2.092e+020          ndep=6e+017
+ nsd=1e+020                phin=0.174                cdsc=0
+ cdscb=0                   cdscd=0                   cit=0.0009+dcitp_hv25_spw
+ lcit=-6e-011+dlcitp_hv25_spw                        wcit=-2e-009+dwcitp_hv25_spw
+ pcit=6e-016+dpcitp_hv25_spw                         voff=-0.116+dvoffp_hv25_spw
+ lvoff=8.4e-009+dlvoffp_hv25_spw                     wvoff=-3e-008+dwvoffp_hv25_spw
+ pvoff=-1.2e-014+dpvoffp_hv25_spw                    nfactor=0.7+dnfactorp_hv25_spw
+ eta0=0.03+deta0p_hv25_spw leta0=1.2e-008            etab=-0.0847
+ ud=0                      lud=0                     wud=0
+ pud=0                     u0=0.008+du0p_hv25_spw    lu0=2.4e-009+dlu0p_hv25_spw
+ wu0=-3e-008+dwu0p_hv25_spw                          pu0=1.8e-014+dpu0p_hv25_spw
+ ua=-3.0406e-010           lua=8.48448e-016          wua=-8.0814e-015
+ pua=4.39692e-021          ub=1.10552e-018           lub=-5.82696e-025
+ wub=1.8284e-024           pub=-1.05642e-030         uc=1.02342e-010
+ luc=-6.7506e-017          wuc=-3.9843e-016          puc=2.04066e-022
+ vsat=90000+dvsatp_hv25_spw                          a0=0.3+da0p_hv25_spw
+ la0=-2.1e-007+dla0p_hv25_spw                        ags=5.8979+dagsp_hv25_spw
+ lags=-1.31772e-006+dlagsp_hv25_spw                  wags=7.947e-006+dwagsp_hv25_spw
+ pags=-2.4456e-012+dpagsp_hv25_spw                   a1=0
+ a2=1                      b0=0                      b1=0
+ keta=-0.033369            lketa=-5.7204e-009        wketa=-2.7807e-007
+ pketa=5.7204e-014         dwg=0                     dwb=0
+ pclm=-0.1                 lpclm=1.5e-007            pdiblc1=0
+ pdiblc2=0.0001            pdiblcb=0                 drout=0.56
+ pvag=0                    delta=0.01                pscbe1=9.264e+008
+ pscbe2=1e-020             fprout=100                pdits=0
+ pditsd=0                  rsh=1.520000e+01          rsw=100
+ rdw=2088                  prwg=0                    prwb=0
+ wr=1                      alpha0=1.1625e-008        alpha1=0.040625
+ beta0=28.8                agidl=5e-008+dagidlp_hv25_spw
+ bgidl=4.111e+009+dbgidlp_hv25_spw                   lbgidl=120+dlbgidlp_hv25_spw
+ wbgidl=300+dwbgidlp_hv25_spw                        pbgidl=-0.0005916+dpbgidlp_hv25_spw
+ cgidl=10                  egidl=0.902               aigbacc=0.01238
+ bigbacc=0.006109          cigbacc=0.2809            nigbacc=4.05
+ aigbinv=0.35              bigbinv=0.03              cigbinv=0.006
+ eigbinv=1.1               nigbinv=1                 aigc=0.009898
+ bigc=0.001383             cigc=1.515e-005           aigsd=0.0086
+ bigsd=0.0004353           cigsd=3.925e-020          nigc=1
+ poxedge=1                 pigcd=1.672               ntox=1
+ xrcrg1=12                 xrcrg2=1                  cgso=cgsop_hv25_spw
+ cgdo=cgdop_hv25_spw       cgbo=0                    cgdl=cgdlp_hv25_spw
+ cgsl=cgslp_hv25_spw       clc=1e-007                cle=0.6
+ cf=cfp_hv25_spw           ckappas=0.6               ckappad=0.6
+ acde=0.7                  moin=6.4033               noff=1.7249
+ voffcv=-0.058992          tvoff=0.001               ltvoff=0
+ wtvoff=0                  ptvoff=0                  kt1=-0.3158+dkt1p_hv25_spw
+ lkt1=-1.7244e-008+dlkt1p_hv25_spw                   wkt1=-1.266e-007+dwkt1p_hv25_spw
+ pkt1=9.534e-014+dpkt1p_hv25_spw                     kt1l=0
+ kt2=-0.025493             lkt2=2.6988e-009          wkt2=-2.4745e-007
+ pkt2=-1.3494e-014         ute=-1.5                  ua1=7.1081e-010
+ lua1=-6.93336e-016        wua1=-9.5665e-015         pua1=4.32048e-021
+ ub1=-1.71219e-018         lub1=7.65324e-025         wub1=1.41706e-023
+ pub1=-5.26446e-030        uc1=3.8065e-011           prt=0
+ at=-120000+datp_hv25_spw  jss=1.540000e-07          jsws=4.710000e-13
+ jswgs=4.710000e-13        njs=1.02                  njd=1.02
+ ijthsfwd=0.01             ijthdfwd=0.01             ijthsrev=0.01
+ ijthdrev=0.01             bvs=8.700000e+00          xjbvs=1
+ xjbvd=1                   jsd=1.012800e-07          jswd=3.752600e-13
+ jswgd=3.752600e-13        bvd=1.430000e+01          jtsswgs=1e-010+djtsswgsp_hv25_spw
+ jtsswgd=5.3e-009+djtsswgdp_hv25_spw                 njtsswg=9+dnjtsswgp_hv25_spw
+ xtsswgs=0.1               xtsswgd=0.43              tnjtsswg=1
+ vtsswgs=1                 vtsswgd=1                 pbs=8.000000e-01
+ cjs=cjsp_hv25_spw         mjs=3.400000e-01          pbsws=4.500000e-01
+ cjsws=cjswsp_hv25_spw     mjsws=1.480000e-01        pbswgs=5.500000e-01
+ cjswgs=cjswgsp_hv25_spw   mjswgs=4.500000e-01       pbd=6.600000e-01
+ cjd=cjdp_hv25_spw         mjd=3.300000e-01          pbswd=6.500000e-01
+ cjswd=cjswdp_hv25_spw     mjswd=3.400000e-01        pbswgd=7.000000e-01
+ cjswgd=cjswgdp_hv25_spw   mjswgd=4.000000e-01       tpb=1.550000e-03
+ tcj=1.100000e-03          tpbsw=1.550000e-03        tcjsw=1.100000e-03
+ tpbswg=1.500000e-03       tcjswg=1.170000e-03       xtis=3
+ xtid=3                    dmcg=5.800000e-08         dmci=5.800000e-08
+ dmdg=0                    dmcgt=0                   dwj=0
+ xgw=0                     xgl=-8.200000e-09         rshg=1.410000e+01
+ gbmin=1e-012              rbpb=50                   rbpd=50
+ rbps=50                   rbdb=50                   rbsb=50
+ ngcon=1                   wa0=0+dwa0p_hv25_spw      pa0=0+dpa0p_hv25_spw
+ lvsat=0+dlvsatp_hv25_spw  wnfactor=0+dwnfactorp_hv25_spw
+ lnfactor=0+dlnfactorp_hv25_spw                      pnfactor=0+dpnfactorp_hv25_spw
+ pvsat=0+dpvsatp_hv25_spw  wvsat=0+dwvsatp_hv25_spw  lat=0+dlatp_hv25_spw
+ wat=0+dwatp_hv25_spw      pat=0+dpatp_hv25_spw      lagidl=0+dlagidlp_hv25_spw
+ wagidl=0+dwagidlp_hv25_spw                          pagidl=0+dpagidlp_hv25_spw
+ minr=1e-3

     10: type=p
+ lmin=1e-005-dxlp_hv25_spw lmax=0.000900001          wmin=1e-06
+ wmax=5e-006-dxwp_hv25_spw version=4.5               binunit=2
+ paramchk=1                mobmod=0                  capmod=2
+ igcmod=0                  igbmod=0                  diomod=1
+ rdsmod=1                  rbodymod=0                rgeomod=1
+ rgatemod=1*rgflag_hv25_snw_spw                      permod=1
+ acnqsmod=0                trnqsmod=0                tempmod=0
+ tnom=25                   toxe=toxp_hv25_spw        toxm=6.13e-009
+ dtox=3.9839e-010          epsrox=3.9                wint=0
+ lint=1.61e-007            ll=0                      wl=0
+ lln=1                     wln=1                     lw=0
+ ww=0                      lwn=1                     wwn=1
+ lwl=0                     wwl=0                     llc=0
+ wlc=0                     lwc=0                     wwc=0
+ lwlc=0                    wwlc=0                    xl=2.2e-08+dxlp_hv25_spw
+ xw=0+dxwp_hv25_spw        dlc=ddlcp_hv25_spw        dwc=0
+ xpart=1                   toxref=3e-009             dlcig=2.5e-009
+ vth0=-0.750205+dvthp_hv25_spw                       wvth0=1.1925e-008+dwvthp_hv25_spw
+ k1=0.52871                k2=0.0522005              wk2=-1.26425e-008
+ k3=-2.3465                k3b=1                     w0=0
+ dvt0=0.85946              dvt1=0.034455             dvt2=0
+ dvt0w=0                   dvt1w=0                   dvt2w=0
+ dsub=0.33                 minv=-0.29912             voffl=-5e-009
+ dvtp0=3e-007              dvtp1=0.1                 lpe0=6.3e-008
+ lpeb=3.1121e-009          xj=8.5e-008               ngate=2.092e+020
+ ndep=6e+017               nsd=1e+020                phin=0.174
+ cdsc=0                    cdscb=0                   cdscd=0
+ cit=0.000575+dcitp_hv25_spw                         wcit=1.25e-010+dwcitp_hv25_spw
+ voff=-0.1275+dvoffp_hv25_spw                        wvoff=-3.75e-008+dwvoffp_hv25_spw
+ nfactor=0.7+dnfactorp_hv25_spw                      eta0=0.05+deta0p_hv25_spw
+ etab=-0.0847              ud=0                      lud=0
+ wud=0                     pud=0                     u0=0.01125+du0p_hv25_spw
+ wu0=3.75e-009+dwu0p_hv25_spw                        ua=1.258475e-009
+ wua=7.56125e-016          ub=6.32055e-020           lub=2.4514298e-033
+ wub=1.32225e-026          pub=-1.2257149e-038       uc=-1.541e-011
+ wuc=-3.211e-017           vsat=90000+dvsatp_hv25_spw
+ a0=-0.13161375+da0p_hv25_spw                        la0=9.8057193e-015+dla0p_hv25_spw
+ wa0=8.971875e-008+dwa0p_hv25_spw                    pa0=-4.9028595e-020+dpa0p_hv25_spw
+ ags=3.381675+dagsp_hv25_spw                         lags=9.8057189e-013+dlagsp_hv25_spw
+ wags=1.822125e-006+dwagsp_hv25_spw                  pags=6.1897453e-028+dpagsp_hv25_spw
+ a1=0                      a2=1                      b0=0
+ b1=0                      keta=-0.085209            wketa=2.88e-008
+ dwg=0                     dwb=0                     pclm=0.05
+ pdiblc1=0                 pdiblc2=0.0001            pdiblcb=0
+ drout=0.56                pvag=0                    delta=0.01
+ pscbe1=9.264e+008         pscbe2=1e-020             fprout=100
+ pdits=0                   pditsd=0                  rsh=1.520000e+01
+ rsw=100                   rdw=2088                  prwg=0
+ prwb=0                    wr=1                      alpha0=1.1625e-008
+ alpha1=0.040625           beta0=28.8                agidl=5e-008+dagidlp_hv25_spw
+ bgidl=4.2465e+009+dbgidlp_hv25_spw                  wbgidl=-504.5+dwbgidlp_hv25_spw
+ cgidl=10                  egidl=0.902               aigbacc=0.01238
+ bigbacc=0.006109          cigbacc=0.2809            nigbacc=4.05
+ aigbinv=0.35              bigbinv=0.03              cigbinv=0.006
+ eigbinv=1.1               nigbinv=1                 aigc=0.009898
+ bigc=0.001383             cigc=1.515e-005           aigsd=0.0086
+ bigsd=0.0004353           cigsd=3.925e-020          nigc=1
+ poxedge=1                 pigcd=1.672               ntox=1
+ xrcrg1=12                 xrcrg2=1                  cgso=cgsop_hv25_spw
+ cgdo=cgdop_hv25_spw       cgbo=0                    cgdl=cgdlp_hv25_spw
+ cgsl=cgslp_hv25_spw       clc=1e-007                cle=0.6
+ cf=cfp_hv25_spw           ckappas=0.6               ckappad=0.6
+ acde=0.7                  moin=6.4033               noff=1.7249
+ voffcv=-0.058992          tvoff=0.001               ltvoff=0
+ wtvoff=0                  ptvoff=0                  kt1=-0.344665+dkt1p_hv25_spw
+ wkt1=3.2925e-008+dwkt1p_hv25_spw                    kt1l=0
+ kt2=-0.074983             ute=-1.5                  ua1=-1.17933e-009
+ wua1=1.3072e-015          ub1=1.2032125e-018        wub1=-2.8028125e-024
+ uc1=3.8065e-011           prt=0                     at=-120000+datp_hv25_spw
+ jss=1.540000e-07          jsws=4.710000e-13         jswgs=4.710000e-13
+ njs=1.02                  njd=1.02                  ijthsfwd=0.01
+ ijthdfwd=0.01             ijthsrev=0.01             ijthdrev=0.01
+ bvs=8.700000e+00          xjbvs=1                   xjbvd=1
+ jsd=1.012800e-07          jswd=3.752600e-13         jswgd=3.752600e-13
+ bvd=1.430000e+01          jtsswgs=1e-010+djtsswgsp_hv25_spw
+ jtsswgd=5.3e-009+djtsswgdp_hv25_spw                 njtsswg=9+dnjtsswgp_hv25_spw
+ xtsswgs=0.1               xtsswgd=0.43              tnjtsswg=1
+ vtsswgs=1                 vtsswgd=1                 pbs=8.000000e-01
+ cjs=cjsp_hv25_spw         mjs=3.400000e-01          pbsws=4.500000e-01
+ cjsws=cjswsp_hv25_spw     mjsws=1.480000e-01        pbswgs=5.500000e-01
+ cjswgs=cjswgsp_hv25_spw   mjswgs=4.500000e-01       pbd=6.600000e-01
+ cjd=cjdp_hv25_spw         mjd=3.300000e-01          pbswd=6.500000e-01
+ cjswd=cjswdp_hv25_spw     mjswd=3.400000e-01        pbswgd=7.000000e-01
+ cjswgd=cjswgdp_hv25_spw   mjswgd=4.000000e-01       tpb=1.550000e-03
+ tcj=1.100000e-03          tpbsw=1.550000e-03        tcjsw=1.100000e-03
+ tpbswg=1.500000e-03       tcjswg=1.170000e-03       xtis=3
+ xtid=3                    dmcg=5.800000e-08         dmci=5.800000e-08
+ dmdg=0                    dmcgt=0                   dwj=0
+ xgw=0                     xgl=-8.200000e-09         rshg=1.410000e+01
+ gbmin=1e-012              rbpb=50                   rbpd=50
+ rbps=50                   rbdb=50                   rbsb=50
+ ngcon=1                   lvth0=0+dlvthp_hv25_spw   pvth0=0+dpvthp_hv25_spw
+ lcit=0+dlcitp_hv25_spw    pcit=0+dpcitp_hv25_spw    lu0=0+dlu0p_hv25_spw
+ pu0=0+dpu0p_hv25_spw      lvsat=0+dlvsatp_hv25_spw  wnfactor=0+dwnfactorp_hv25_spw
+ lnfactor=0+dlnfactorp_hv25_spw                      pnfactor=0+dpnfactorp_hv25_spw
+ pvsat=0+dpvsatp_hv25_spw  wvsat=0+dwvsatp_hv25_spw  lvoff=0+dlvoffp_hv25_spw
+ pvoff=0+dpvoffp_hv25_spw  lkt1=0+dlkt1p_hv25_spw    pkt1=0+dpkt1p_hv25_spw
+ lat=0+dlatp_hv25_spw      wat=0+dwatp_hv25_spw      pat=0+dpatp_hv25_spw
+ lagidl=0+dlagidlp_hv25_spw                          wagidl=0+dwagidlp_hv25_spw
+ pagidl=0+dpagidlp_hv25_spw                          lbgidl=0+dlbgidlp_hv25_spw
+ pbgidl=0+dpbgidlp_hv25_spw                          minr=1e-3

     11: type=p
+ lmin=9e-007-dxlp_hv25_spw lmax=1e-005-dxlp_hv25_spw wmin=1e-06
+ wmax=5e-006-dxwp_hv25_spw version=4.5               binunit=2
+ paramchk=1                mobmod=0                  capmod=2
+ igcmod=0                  igbmod=0                  diomod=1
+ rdsmod=1                  rbodymod=0                rgeomod=1
+ rgatemod=1*rgflag_hv25_snw_spw                      permod=1
+ acnqsmod=0                trnqsmod=0                tempmod=0
+ tnom=25                   toxe=toxp_hv25_spw        toxm=6.13e-009
+ dtox=3.9839e-010          epsrox=3.9                wint=0
+ lint=1.61e-007            ll=0                      wl=0
+ lln=1                     wln=1                     lw=0
+ ww=0                      lwn=1                     wwn=1
+ lwl=0                     wwl=0                     llc=0
+ wlc=0                     lwc=0                     wwc=0
+ lwlc=0                    wwlc=0                    xl=2.2e-08+dxlp_hv25_spw
+ xw=0+dxwp_hv25_spw        dlc=ddlcp_hv25_spw        dwc=0
+ xpart=1                   toxref=3e-009             dlcig=2.5e-009
+ vth0=-0.75793198+dvthp_hv25_spw                     lvth0=7.4951687e-008+dlvthp_hv25_spw
+ wvth0=1.4012637e-008+dwvthp_hv25_spw                pvth0=-2.0250082e-014+dpvthp_hv25_spw
+ k1=0.52871                k2=0.0522005              wk2=-1.26425e-008
+ k3=-2.3465                k3b=1                     w0=0
+ dvt0=0.85946              dvt1=0.034455             dvt2=0
+ dvt0w=0                   dvt1w=0                   dvt2w=0
+ dsub=0.33                 minv=-0.29912             voffl=-5e-009
+ dvtp0=3e-007              dvtp1=0.1                 lpe0=6.3e-008
+ lpeb=3.1121e-009          xj=8.5e-008               ngate=2.092e+020
+ ndep=6e+017               nsd=1e+020                phin=0.174
+ cdsc=0                    cdscb=0                   cdscd=0
+ cit=0.000575+dcitp_hv25_spw                         wcit=1.25e-010+dwcitp_hv25_spw
+ voff=-0.12898352+dvoffp_hv25_spw                    lvoff=1.439011e-008+dlvoffp_hv25_spw
+ wvoff=-3.7664835e-008+dwvoffp_hv25_spw              pvoff=1.5989011e-015+dpvoffp_hv25_spw
+ nfactor=0.7+dnfactorp_hv25_spw                      eta0=0.05+deta0p_hv25_spw
+ etab=-0.0847              ud=0                      lud=0
+ wud=0                     pud=0                     u0=0.011282967+du0p_hv25_spw
+ lu0=-3.1978022e-010+dlu0p_hv25_spw                  wu0=3.5851648e-009+dwu0p_hv25_spw
+ pu0=1.5989011e-015+dpu0p_hv25_spw                   ua=1.2944354e-009
+ lua=-3.4881626e-016       wua=7.2477995e-016        pua=3.0404703e-022
+ ub=5.2928061e-020         lub=9.9691164e-026        wub=3.7560246e-026
+ pub=-2.3607615e-031       uc=-1.541e-011            wuc=-3.211e-017
+ vsat=90000+dvsatp_hv25_spw                          a0=-0.13666521+da0p_hv25_spw
+ la0=4.8999123e-008+dla0p_hv25_spw                   wa0=9.3985915e-008+dwa0p_hv25_spw
+ pa0=-4.1391549e-014+dpa0p_hv25_spw                  ags=3.3215267+dagsp_hv25_spw
+ lags=5.8343895e-007+dlagsp_hv25_spw                 wags=1.8822734e-006+dwagsp_hv25_spw
+ pags=-5.8343901e-013+dpagsp_hv25_spw                a1=0
+ a2=1                      b0=0                      b1=0
+ keta=-0.085209            wketa=2.88e-008           dwg=0
+ dwb=0                     pclm=0.043736264          lpclm=6.0758242e-008
+ wpclm=-1.6483516e-009     ppclm=1.5989011e-014      pdiblc1=0
+ pdiblc2=0.0001            pdiblcb=0                 drout=0.56
+ pvag=0                    delta=0.01                pscbe1=9.264e+008
+ pscbe2=1e-020             fprout=100                pdits=0
+ pditsd=0                  rsh=1.520000e+01          rsw=100
+ rdw=2088                  prwg=0                    prwb=0
+ wr=1                      alpha0=1.1625e-008        alpha1=0.040625
+ beta0=28.8                agidl=5e-008+dagidlp_hv25_spw
+ bgidl=4.2437687e+009+dbgidlp_hv25_spw               lbgidl=26.493791+dlbgidlp_hv25_spw
+ wbgidl=-500.14011+dwbgidlp_hv25_spw                 pbgidl=-4.2290934e-005+dpbgidlp_hv25_spw
+ cgidl=10                  egidl=0.902               aigbacc=0.01238
+ bigbacc=0.006109          cigbacc=0.2809            nigbacc=4.05
+ aigbinv=0.35              bigbinv=0.03              cigbinv=0.006
+ eigbinv=1.1               nigbinv=1                 aigc=0.009898
+ bigc=0.001383             cigc=1.515e-005           aigsd=0.0086
+ bigsd=0.0004353           cigsd=3.925e-020          nigc=1
+ poxedge=1                 pigcd=1.672               ntox=1
+ xrcrg1=12                 xrcrg2=1                  cgso=cgsop_hv25_spw
+ cgdo=cgdop_hv25_spw       cgbo=0                    cgdl=cgdlp_hv25_spw
+ cgsl=cgslp_hv25_spw       clc=1e-007                cle=0.6
+ cf=cfp_hv25_spw           ckappas=0.6               ckappad=0.6
+ acde=0.7                  moin=6.4033               noff=1.7249
+ voffcv=-0.058992          tvoff=0.001               ltvoff=0
+ wtvoff=0                  ptvoff=0                  kt1=-0.344665+dkt1p_hv25_spw
+ wkt1=3.2925e-008+dwkt1p_hv25_spw                    kt1l=0
+ kt2=-0.074983             ute=-1.5                  ua1=-1.17933e-009
+ wua1=1.3072e-015          ub1=1.2032125e-018        wub1=-2.8028125e-024
+ uc1=3.8065e-011           prt=0                     at=-120000+datp_hv25_spw
+ jss=1.540000e-07          jsws=4.710000e-13         jswgs=4.710000e-13
+ njs=1.02                  njd=1.02                  ijthsfwd=0.01
+ ijthdfwd=0.01             ijthsrev=0.01             ijthdrev=0.01
+ bvs=8.700000e+00          xjbvs=1                   xjbvd=1
+ jsd=1.012800e-07          jswd=3.752600e-13         jswgd=3.752600e-13
+ bvd=1.430000e+01          jtsswgs=1e-010+djtsswgsp_hv25_spw
+ jtsswgd=5.3e-009+djtsswgdp_hv25_spw                 njtsswg=9+dnjtsswgp_hv25_spw
+ xtsswgs=0.1               xtsswgd=0.43              tnjtsswg=1
+ vtsswgs=1                 vtsswgd=1                 pbs=8.000000e-01
+ cjs=cjsp_hv25_spw         mjs=3.400000e-01          pbsws=4.500000e-01
+ cjsws=cjswsp_hv25_spw     mjsws=1.480000e-01        pbswgs=5.500000e-01
+ cjswgs=cjswgsp_hv25_spw   mjswgs=4.500000e-01       pbd=6.600000e-01
+ cjd=cjdp_hv25_spw         mjd=3.300000e-01          pbswd=6.500000e-01
+ cjswd=cjswdp_hv25_spw     mjswd=3.400000e-01        pbswgd=7.000000e-01
+ cjswgd=cjswgdp_hv25_spw   mjswgd=4.000000e-01       tpb=1.550000e-03
+ tcj=1.100000e-03          tpbsw=1.550000e-03        tcjsw=1.100000e-03
+ tpbswg=1.500000e-03       tcjswg=1.170000e-03       xtis=3
+ xtid=3                    dmcg=5.800000e-08         dmci=5.800000e-08
+ dmdg=0                    dmcgt=0                   dwj=0
+ xgw=0                     xgl=-8.200000e-09         rshg=1.410000e+01
+ gbmin=1e-012              rbpb=50                   rbpd=50
+ rbps=50                   rbdb=50                   rbsb=50
+ ngcon=1                   lcit=0+dlcitp_hv25_spw    pcit=0+dpcitp_hv25_spw
+ lvsat=0+dlvsatp_hv25_spw  wnfactor=0+dwnfactorp_hv25_spw
+ lnfactor=0+dlnfactorp_hv25_spw                      pnfactor=0+dpnfactorp_hv25_spw
+ pvsat=0+dpvsatp_hv25_spw  wvsat=0+dwvsatp_hv25_spw  lkt1=0+dlkt1p_hv25_spw
+ pkt1=0+dpkt1p_hv25_spw    lat=0+dlatp_hv25_spw      wat=0+dwatp_hv25_spw
+ pat=0+dpatp_hv25_spw      lagidl=0+dlagidlp_hv25_spw
+ wagidl=0+dwagidlp_hv25_spw                          pagidl=0+dpagidlp_hv25_spw
+ minr=1e-3

     12: type=p
+ lmin=5.94e-07             lmax=9e-007-dxlp_hv25_spw wmin=1e-06
+ wmax=5e-006-dxwp_hv25_spw version=4.5               binunit=2
+ paramchk=1                mobmod=0                  capmod=2
+ igcmod=0                  igbmod=0                  diomod=1
+ rdsmod=1                  rbodymod=0                rgeomod=1
+ rgatemod=1*rgflag_hv25_snw_spw                      permod=1
+ acnqsmod=0                trnqsmod=0                tempmod=0
+ tnom=25                   toxe=toxp_hv25_spw        toxm=6.13e-009
+ dtox=3.9839e-010          epsrox=3.9                wint=0
+ lint=1.61e-007            ll=0                      wl=0
+ lln=1                     wln=1                     lw=0
+ ww=0                      lwn=1                     wwn=1
+ lwl=0                     wwl=0                     llc=0
+ wlc=0                     lwc=0                     wwc=0
+ lwlc=0                    wwlc=0                    xl=2.2e-08+dxlp_hv25_spw
+ xw=0+dxwp_hv25_spw        dlc=ddlcp_hv25_spw        dwc=0
+ xpart=1                   toxref=3e-009             dlcig=2.5e-009
+ vth0=-0.627095+dvthp_hv25_spw                       lvth0=-3.5505e-009+dlvthp_hv25_spw
+ wvth0=-3.3425e-008+dwvthp_hv25_spw                  pvth0=8.2125e-015+dpvthp_hv25_spw
+ k1=0.52871                k2=0.072116               lk2=-1.19493e-008
+ wk2=-7.06e-009            pk2=-3.3495e-015          k3=-2.3465
+ k3b=1                     w0=0                      dvt0=0.85946
+ dvt1=0.034455             dvt2=0                    dvt0w=0
+ dvt1w=0                   dvt2w=0                   dsub=0.33
+ minv=-0.29912             voffl=-5e-009             dvtp0=3e-007
+ dvtp1=0.1                 lpe0=6.3e-008             lpeb=3.1121e-009
+ xj=8.5e-008               ngate=2.092e+020          ndep=6e+017
+ nsd=1e+020                phin=0.174                cdsc=0
+ cdscb=0                   cdscd=0                   cit=0.000475+dcitp_hv25_spw
+ lcit=6e-011+dlcitp_hv25_spw                         wcit=1.25e-010+dwcitp_hv25_spw
+ pcit=3.0493186e-031+dpcitp_hv25_spw                 voff=-0.115+dvoffp_hv25_spw
+ lvoff=6e-009+dlvoffp_hv25_spw                       wvoff=-3.5e-008+dwvoffp_hv25_spw
+ pvoff=7.8062556e-030+dpvoffp_hv25_spw               nfactor=0.7+dnfactorp_hv25_spw
+ eta0=0.03+deta0p_hv25_spw leta0=1.2e-008            etab=-0.0847
+ ud=0                      lud=0                     wud=0
+ pud=0                     u0=0.001+du0p_hv25_spw    lu0=5.85e-009+dlu0p_hv25_spw
+ wu0=5e-009+dwu0p_hv25_spw pu0=7.5e-016+dpu0p_hv25_spw
+ ua=-2.177125e-009         lua=1.73412e-015          wua=1.283925e-015
+ pua=-3.144e-023           ub=1.43456e-018           lub=-7.29288e-025
+ wub=1.832e-025            pub=-3.2346e-031          uc=1.696e-011
+ luc=-1.9422e-017          wuc=2.848e-017            puc=-3.6354e-023
+ vsat=90000+dvsatp_hv25_spw                          a0=0.29+da0p_hv25_spw
+ la0=-2.07e-007+dla0p_hv25_spw                       wa0=5e-008+dwa0p_hv25_spw
+ pa0=-1.5e-014+dpa0p_hv25_spw                        ags=7.2916+dagsp_hv25_spw
+ lags=-1.798605e-006+dlagsp_hv25_spw                 wags=9.785e-007+dwagsp_hv25_spw
+ pags=-4.1175e-014+dpagsp_hv25_spw                   a1=0
+ a2=1                      b0=0                      b1=0
+ keta=-0.094743            lketa=5.7204e-009         wketa=2.88e-008
+ pketa=-1.1709383e-029     dwg=0                     dwb=0
+ pclm=-0.085               lpclm=1.38e-007           wpclm=-7.5e-008
+ ppclm=6e-014              pdiblc1=0                 pdiblc2=0.000125
+ lpdiblc2=-1.5e-011        wpdiblc2=-1.25e-010       ppdiblc2=7.5e-017
+ pdiblcb=0                 drout=0.56                pvag=0
+ delta=0.01                pscbe1=9.264e+008         pscbe2=1e-020
+ fprout=100                pdits=0                   pditsd=0
+ rsh=1.520000e+01          rsw=100                   rdw=2088
+ prwg=0                    prwb=0                    wr=1
+ alpha0=1.1625e-008        alpha1=0.040625           beta0=28.8
+ agidl=5e-008+dagidlp_hv25_spw                       bgidl=4.289425e+009+dbgidlp_hv25_spw
+ lbgidl=-0.9+dlbgidlp_hv25_spw                       wbgidl=-592.125+dwbgidlp_hv25_spw
+ pbgidl=1.29e-005+dpbgidlp_hv25_spw                  cgidl=10
+ egidl=0.902               aigbacc=0.01238           bigbacc=0.006109
+ cigbacc=0.2809            nigbacc=4.05              aigbinv=0.35
+ bigbinv=0.03              cigbinv=0.006             eigbinv=1.1
+ nigbinv=1                 aigc=0.009898             bigc=0.001383
+ cigc=1.515e-005           aigsd=0.0086              bigsd=0.0004353
+ cigsd=3.925e-020          nigc=1                    poxedge=1
+ pigcd=1.672               ntox=1                    xrcrg1=12
+ xrcrg2=1                  cgso=cgsop_hv25_spw       cgdo=cgdop_hv25_spw
+ cgbo=0                    cgdl=cgdlp_hv25_spw       cgsl=cgslp_hv25_spw
+ clc=1e-007                cle=0.6                   cf=cfp_hv25_spw
+ ckappas=0.6               ckappad=0.6               acde=0.7
+ moin=6.4033               noff=1.7249               voffcv=-0.058992
+ tvoff=0.001               ltvoff=0                  wtvoff=0
+ ptvoff=0                  kt1=-0.349035+dkt1p_hv25_spw
+ lkt1=2.622e-009+dlkt1p_hv25_spw                     wkt1=3.9575e-008+dwkt1p_hv25_spw
+ pkt1=-3.99e-015+dpkt1p_hv25_spw                     kt1l=0
+ kt2=-0.074983             ute=-1.5                  ua1=-1.813655e-009
+ lua1=3.80595e-016         wua1=3.055825e-015        pua1=-1.049175e-021
+ ub1=2.2272125e-018        lub1=-6.144e-025          wub1=-5.5264125e-024
+ pub1=1.63416e-030         uc1=3.8065e-011           prt=0
+ at=-120000+datp_hv25_spw  jss=1.540000e-07          jsws=4.710000e-13
+ jswgs=4.710000e-13        njs=1.02                  njd=1.02
+ ijthsfwd=0.01             ijthdfwd=0.01             ijthsrev=0.01
+ ijthdrev=0.01             bvs=8.700000e+00          xjbvs=1
+ xjbvd=1                   jsd=1.012800e-07          jswd=3.752600e-13
+ jswgd=3.752600e-13        bvd=1.430000e+01          jtsswgs=1e-010+djtsswgsp_hv25_spw
+ jtsswgd=5.3e-009+djtsswgdp_hv25_spw                 njtsswg=9+dnjtsswgp_hv25_spw
+ xtsswgs=0.1               xtsswgd=0.43              tnjtsswg=1
+ vtsswgs=1                 vtsswgd=1                 pbs=8.000000e-01
+ cjs=cjsp_hv25_spw         mjs=3.400000e-01          pbsws=4.500000e-01
+ cjsws=cjswsp_hv25_spw     mjsws=1.480000e-01        pbswgs=5.500000e-01
+ cjswgs=cjswgsp_hv25_spw   mjswgs=4.500000e-01       pbd=6.600000e-01
+ cjd=cjdp_hv25_spw         mjd=3.300000e-01          pbswd=6.500000e-01
+ cjswd=cjswdp_hv25_spw     mjswd=3.400000e-01        pbswgd=7.000000e-01
+ cjswgd=cjswgdp_hv25_spw   mjswgd=4.000000e-01       tpb=1.550000e-03
+ tcj=1.100000e-03          tpbsw=1.550000e-03        tcjsw=1.100000e-03
+ tpbswg=1.500000e-03       tcjswg=1.170000e-03       xtis=3
+ xtid=3                    dmcg=5.800000e-08         dmci=5.800000e-08
+ dmdg=0                    dmcgt=0                   dwj=0
+ xgw=0                     xgl=-8.200000e-09         rshg=1.410000e+01
+ gbmin=1e-012              rbpb=50                   rbpd=50
+ rbps=50                   rbdb=50                   rbsb=50
+ ngcon=1                   lvsat=0+dlvsatp_hv25_spw  wnfactor=0+dwnfactorp_hv25_spw
+ lnfactor=0+dlnfactorp_hv25_spw                      pnfactor=0+dpnfactorp_hv25_spw
+ pvsat=0+dpvsatp_hv25_spw  wvsat=0+dwvsatp_hv25_spw  lat=0+dlatp_hv25_spw
+ wat=0+dwatp_hv25_spw      pat=0+dpatp_hv25_spw      lagidl=0+dlagidlp_hv25_spw
+ wagidl=0+dwagidlp_hv25_spw                          pagidl=0+dpagidlp_hv25_spw
+ minr=1e-3

     }
endsection mos_hv25_snw_spw
endlibrary tsmclib
