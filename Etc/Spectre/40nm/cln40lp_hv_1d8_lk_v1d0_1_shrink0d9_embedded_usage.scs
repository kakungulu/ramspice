section pre_simu
setscale options scalefactor=0.9
parOpt options redefinedparams=ignore
parameters ccoflag_hv18_snw_spw=1
parameters rgflag_hv18_snw_spw=1
endsection pre_simu

section tt_hv18
setscale options scalefactor=0.9
include "cln40lp_hv_1d8_lk_v1d0_1.scs" section=tt_hv18_snw_spw
parOpt options redefinedparams=ignore
endsection tt_hv18

section ss_hv18
setscale options scalefactor=0.9
include "cln40lp_hv_1d8_lk_v1d0_1.scs" section=ss_hv18_snw_spw
parOpt options redefinedparams=ignore
endsection ss_hv18

section ff_hv18
setscale options scalefactor=0.9
include "cln40lp_hv_1d8_lk_v1d0_1.scs" section=ff_hv18_snw_spw
parOpt options redefinedparams=ignore
endsection ff_hv18

section sf_hv18
setscale options scalefactor=0.9
include "cln40lp_hv_1d8_lk_v1d0_1.scs" section=sf_hv18_snw_spw
parOpt options redefinedparams=ignore
endsection sf_hv18

section fs_hv18
setscale options scalefactor=0.9
include "cln40lp_hv_1d8_lk_v1d0_1.scs" section=fs_hv18_snw_spw
parOpt options redefinedparams=ignore
endsection fs_hv18
